Vin vin 0 AC 1
Rin vin vout 1e12
L1 vout 0 1.001302e-03
C1 vout 0 9.998601e-09
Rload vout 0 1000
