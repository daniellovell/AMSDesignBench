M750990031 N003 vip N005 0 nch W=2u L=0.18u
M59813637 N004 vin N005 0 nch W=2u L=0.18u
M895683689 voutn vb3 N003 0 nch W=1u L=0.18u
M430638185 voutp vb3 N004 0 nch W=1u L=0.18u
M558567410 N005 vtail 0 0 nch W=1u L=0.5u
M872983735 voutn vb2 N001 VDD pch W=2u L=0.18u
M461371498 voutp vb2 N002 VDD pch W=2u L=0.18u
M416776548 N001 vb1 VDD VDD pch W=4u L=0.18u
M765829905 N002 vb1 VDD VDD pch W=4u L=0.18u
C676229428 voutp 0 1p
C108806681 voutn 0 1p
VDD VDD 0 1.8
