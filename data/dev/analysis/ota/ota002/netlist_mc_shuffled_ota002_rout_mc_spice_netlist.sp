M50879853 N003 vip N005 0 nch W=2u L=0.18u
M521337146 N004 vin N005 0 nch W=2u L=0.18u
M969220059 voutn vb3 N003 0 nch W=1u L=0.18u
M410663404 voutp vb3 N004 0 nch W=1u L=0.18u
M482656453 N005 vtail 0 0 nch W=1u L=0.5u
M70645144 voutn vb2 N001 VDD pch W=2u L=0.18u
M860179234 voutp vb2 N002 VDD pch W=2u L=0.18u
M857189290 N001 vb1 VDD VDD pch W=4u L=0.18u
M74668631 N002 vb1 VDD VDD pch W=4u L=0.18u
C382067943 voutp 0 1p
C508844658 voutn 0 1p
VDD VDD 0 1.8
