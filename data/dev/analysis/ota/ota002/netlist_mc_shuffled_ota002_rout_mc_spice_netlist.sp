M178346216 N003 vip N005 0 nch W=2u L=0.18u
M120789530 N004 vin N005 0 nch W=2u L=0.18u
M846068233 voutn vb3 N003 0 nch W=1u L=0.18u
M302931671 voutp vb3 N004 0 nch W=1u L=0.18u
M686130591 N005 vtail 0 0 nch W=1u L=0.5u
M414686178 voutn vb2 N001 VDD pch W=2u L=0.18u
M786990178 voutp vb2 N002 VDD pch W=2u L=0.18u
M354211348 N001 vb1 VDD VDD pch W=4u L=0.18u
M412844770 N002 vb1 VDD VDD pch W=4u L=0.18u
C155949465 voutp 0 1p
C665195180 voutn 0 1p
VDD VDD 0 1.8
