M513707592 N003 vip N005 0 nch W=2u L=0.18u
M382568243 N004 vin N005 0 nch W=2u L=0.18u
M741409688 voutn vb3 N003 0 nch W=1u L=0.18u
M297220983 voutp vb3 N004 0 nch W=1u L=0.18u
M619493129 N005 vtail 0 0 nch W=1u L=0.5u
M308376702 voutn vb2 N001 VDD pch W=2u L=0.18u
M312313390 voutp vb2 N002 VDD pch W=2u L=0.18u
M876117484 N001 vb1 VDD VDD pch W=4u L=0.18u
M219826575 N002 vb1 VDD VDD pch W=4u L=0.18u
C809918412 voutp 0 1p
C171445116 voutn 0 1p
VDD VDD 0 1.8
