M28762409 N003 vip N005 0 nch W=2u L=0.18u
M325184191 N004 vin N005 0 nch W=2u L=0.18u
M525710928 voutn vb3 N003 0 nch W=1u L=0.18u
M943622652 voutp vb3 N004 0 nch W=1u L=0.18u
M554305354 N005 vtail 0 0 nch W=1u L=0.5u
M841899601 voutn vb2 N001 VDD pch W=2u L=0.18u
M237431028 voutp vb2 N002 VDD pch W=2u L=0.18u
M120039096 N001 vb1 VDD VDD pch W=4u L=0.18u
M601334069 N002 vb1 VDD VDD pch W=4u L=0.18u
C985308448 voutp 0 1p
C268948370 voutn 0 1p
VDD VDD 0 1.8
