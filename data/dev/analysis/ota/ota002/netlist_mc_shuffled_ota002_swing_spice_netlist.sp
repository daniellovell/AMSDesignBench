M994538327 N003 vip N005 0 nch W=2u L=0.18u
M154390534 N004 vin N005 0 nch W=2u L=0.18u
M370341842 voutn vb3 N003 0 nch W=1u L=0.18u
M567458555 voutp vb3 N004 0 nch W=1u L=0.18u
M250105210 N005 vtail 0 0 nch W=1u L=0.5u
M78769584 voutn vb2 N001 VDD pch W=2u L=0.18u
M916225590 voutp vb2 N002 VDD pch W=2u L=0.18u
M761881832 N001 vb1 VDD VDD pch W=4u L=0.18u
M418857135 N002 vb1 VDD VDD pch W=4u L=0.18u
C940600845 voutp 0 1p
C970943408 voutn 0 1p
VDD VDD 0 1.8
