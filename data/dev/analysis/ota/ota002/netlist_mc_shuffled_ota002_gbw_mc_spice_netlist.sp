M34678321 N003 vip N005 0 nch W=2u L=0.18u
M372888764 N004 vin N005 0 nch W=2u L=0.18u
M783384802 voutn vb3 N003 0 nch W=1u L=0.18u
M132586276 voutp vb3 N004 0 nch W=1u L=0.18u
M910468860 N005 vtail 0 0 nch W=1u L=0.5u
M5216241 voutn vb2 N001 VDD pch W=2u L=0.18u
M984182320 voutp vb2 N002 VDD pch W=2u L=0.18u
M34844923 N001 vb1 VDD VDD pch W=4u L=0.18u
M237371074 N002 vb1 VDD VDD pch W=4u L=0.18u
C169389640 voutp 0 1p
C203879070 voutn 0 1p
VDD VDD 0 1.8
