M969129078 N003 vip N005 0 nch W=2u L=0.18u
M974269128 N004 vin N005 0 nch W=2u L=0.18u
M21796752 voutn vb3 N003 0 nch W=1u L=0.18u
M239600953 voutp vb3 N004 0 nch W=1u L=0.18u
M712907716 N005 vtail 0 0 nch W=1u L=0.5u
M983796725 voutn vb2 N001 VDD pch W=2u L=0.18u
M454707522 voutp vb2 N002 VDD pch W=2u L=0.18u
M608572360 N001 vb1 VDD VDD pch W=4u L=0.18u
M973762966 N002 vb1 VDD VDD pch W=4u L=0.18u
C999721636 voutp 0 1p
C474825120 voutn 0 1p
VDD VDD 0 1.8
