M674717190 N003 vip N005 0 nch W=2u L=0.18u
M189751576 N004 vin N005 0 nch W=2u L=0.18u
M842429656 voutn vb3 N003 0 nch W=1u L=0.18u
M404665587 voutp vb3 N004 0 nch W=1u L=0.18u
M255236200 N005 vtail 0 0 nch W=1u L=0.5u
M823616316 voutn vb2 N001 VDD pch W=2u L=0.18u
M19050298 voutp vb2 N002 VDD pch W=2u L=0.18u
M873691113 N001 vb1 VDD VDD pch W=4u L=0.18u
M949469414 N002 vb1 VDD VDD pch W=4u L=0.18u
C878345542 voutp 0 1p
C404155730 voutn 0 1p
VDD VDD 0 1.8
