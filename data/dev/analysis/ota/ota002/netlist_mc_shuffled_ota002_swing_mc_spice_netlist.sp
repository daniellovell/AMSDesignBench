M800166366 N003 vip N005 0 nch W=2u L=0.18u
M377422377 N004 vin N005 0 nch W=2u L=0.18u
M449849796 voutn vb3 N003 0 nch W=1u L=0.18u
M322632220 voutp vb3 N004 0 nch W=1u L=0.18u
M897488926 N005 vtail 0 0 nch W=1u L=0.5u
M832481291 voutn vb2 N001 VDD pch W=2u L=0.18u
M92213476 voutp vb2 N002 VDD pch W=2u L=0.18u
M614202704 N001 vb1 VDD VDD pch W=4u L=0.18u
M199191720 N002 vb1 VDD VDD pch W=4u L=0.18u
C889407873 voutp 0 1p
C86773492 voutn 0 1p
VDD VDD 0 1.8
