M787189544 N003 vip N005 0 nch W=2u L=0.18u
M752576522 N004 vin N005 0 nch W=2u L=0.18u
M80019820 voutn vb3 N003 0 nch W=1u L=0.18u
M574315858 voutp vb3 N004 0 nch W=1u L=0.18u
M434959676 N005 vtail 0 0 nch W=1u L=0.5u
M856044435 voutn vb2 N001 VDD pch W=2u L=0.18u
M444043084 voutp vb2 N002 VDD pch W=2u L=0.18u
M230205371 N001 vb1 VDD VDD pch W=4u L=0.18u
M836035826 N002 vb1 VDD VDD pch W=4u L=0.18u
C271292171 voutp 0 1p
C339691443 voutn 0 1p
VDD VDD 0 1.8
