M863052646 N003 vip N005 0 nch W=2u L=0.18u
M635815099 N004 vin N005 0 nch W=2u L=0.18u
M705245986 voutn vb3 N003 0 nch W=1u L=0.18u
M625999045 voutp vb3 N004 0 nch W=1u L=0.18u
M991246361 N005 vtail 0 0 nch W=1u L=0.5u
M42307753 voutn vb2 N001 VDD pch W=2u L=0.18u
M291871726 voutp vb2 N002 VDD pch W=2u L=0.18u
M292276934 N001 vb1 VDD VDD pch W=4u L=0.18u
M601884562 N002 vb1 VDD VDD pch W=4u L=0.18u
C14257530 voutp 0 1p
C996304474 voutn 0 1p
VDD VDD 0 1.8
