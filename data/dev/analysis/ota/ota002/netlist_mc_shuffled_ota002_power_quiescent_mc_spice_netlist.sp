M903998925 N003 vip N005 0 nch W=2u L=0.18u
M150653835 N004 vin N005 0 nch W=2u L=0.18u
M114109854 voutn vb3 N003 0 nch W=1u L=0.18u
M350373446 voutp vb3 N004 0 nch W=1u L=0.18u
M590728997 N005 vtail 0 0 nch W=1u L=0.5u
M192092355 voutn vb2 N001 VDD pch W=2u L=0.18u
M962384668 voutp vb2 N002 VDD pch W=2u L=0.18u
M979194217 N001 vb1 VDD VDD pch W=4u L=0.18u
M670989159 N002 vb1 VDD VDD pch W=4u L=0.18u
C710057423 voutp 0 1p
C304111068 voutn 0 1p
VDD VDD 0 1.8
