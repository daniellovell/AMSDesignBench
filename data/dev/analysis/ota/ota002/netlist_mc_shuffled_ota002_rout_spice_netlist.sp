M903581246 N003 vip N005 0 nch W=2u L=0.18u
M718408794 N004 vin N005 0 nch W=2u L=0.18u
M105653943 voutn vb3 N003 0 nch W=1u L=0.18u
M628655193 voutp vb3 N004 0 nch W=1u L=0.18u
M13023553 N005 vtail 0 0 nch W=1u L=0.5u
M385396463 voutn vb2 N001 VDD pch W=2u L=0.18u
M511890204 voutp vb2 N002 VDD pch W=2u L=0.18u
M332896818 N001 vb1 VDD VDD pch W=4u L=0.18u
M84583943 N002 vb1 VDD VDD pch W=4u L=0.18u
C240900201 voutp 0 1p
C340341032 voutn 0 1p
VDD VDD 0 1.8
