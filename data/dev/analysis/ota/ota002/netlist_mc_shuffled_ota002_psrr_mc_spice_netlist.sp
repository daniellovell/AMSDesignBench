M392927557 N003 vip N005 0 nch W=2u L=0.18u
M21219794 N004 vin N005 0 nch W=2u L=0.18u
M418307489 voutn vb3 N003 0 nch W=1u L=0.18u
M954687981 voutp vb3 N004 0 nch W=1u L=0.18u
M537598510 N005 vtail 0 0 nch W=1u L=0.5u
M404107611 voutn vb2 N001 VDD pch W=2u L=0.18u
M654747816 voutp vb2 N002 VDD pch W=2u L=0.18u
M705746829 N001 vb1 VDD VDD pch W=4u L=0.18u
M703211532 N002 vb1 VDD VDD pch W=4u L=0.18u
C761022422 voutp 0 1p
C722484819 voutn 0 1p
VDD VDD 0 1.8
