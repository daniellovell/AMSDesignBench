M996327280 N003 vip N005 0 nch W=2u L=0.18u
M379440350 N004 vin N005 0 nch W=2u L=0.18u
M344628097 voutn vb3 N003 0 nch W=1u L=0.18u
M278010883 voutp vb3 N004 0 nch W=1u L=0.18u
M400480056 N005 vtail 0 0 nch W=1u L=0.5u
M726960695 voutn vb2 N001 VDD pch W=2u L=0.18u
M10417893 voutp vb2 N002 VDD pch W=2u L=0.18u
M423648575 N001 vb1 VDD VDD pch W=4u L=0.18u
M866726465 N002 vb1 VDD VDD pch W=4u L=0.18u
C295027736 voutp 0 1p
C582054407 voutn 0 1p
VDD VDD 0 1.8
