M319038731 N003 vip N005 0 nch W=2u L=0.18u
M295069067 N004 vin N005 0 nch W=2u L=0.18u
M352856142 voutn vb3 N003 0 nch W=1u L=0.18u
M812021625 voutp vb3 N004 0 nch W=1u L=0.18u
M235082168 N005 vtail 0 0 nch W=1u L=0.5u
M313836833 voutn vb2 N001 VDD pch W=2u L=0.18u
M773717171 voutp vb2 N002 VDD pch W=2u L=0.18u
M16691245 N001 vb1 VDD VDD pch W=4u L=0.18u
M617948612 N002 vb1 VDD VDD pch W=4u L=0.18u
C704319688 voutp 0 1p
C110860076 voutn 0 1p
VDD VDD 0 1.8
