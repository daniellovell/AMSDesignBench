M937633700 N003 vip N005 0 nch W=2u L=0.18u
M641670788 N004 vin N005 0 nch W=2u L=0.18u
M969518967 voutn vb3 N003 0 nch W=1u L=0.18u
M143083642 voutp vb3 N004 0 nch W=1u L=0.18u
M353655144 N005 vtail 0 0 nch W=1u L=0.5u
M152744087 voutn vb2 N001 VDD pch W=2u L=0.18u
M407386142 voutp vb2 N002 VDD pch W=2u L=0.18u
M265945482 N001 vb1 VDD VDD pch W=4u L=0.18u
M249973048 N002 vb1 VDD VDD pch W=4u L=0.18u
C622445697 voutp 0 1p
C203638259 voutn 0 1p
VDD VDD 0 1.8
