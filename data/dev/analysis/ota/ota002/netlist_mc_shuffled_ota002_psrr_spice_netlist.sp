M576640506 N003 vip N005 0 nch W=2u L=0.18u
M632518255 N004 vin N005 0 nch W=2u L=0.18u
M431913146 voutn vb3 N003 0 nch W=1u L=0.18u
M567423217 voutp vb3 N004 0 nch W=1u L=0.18u
M983662946 N005 vtail 0 0 nch W=1u L=0.5u
M553496033 voutn vb2 N001 VDD pch W=2u L=0.18u
M900353721 voutp vb2 N002 VDD pch W=2u L=0.18u
M871831187 N001 vb1 VDD VDD pch W=4u L=0.18u
M59787790 N002 vb1 VDD VDD pch W=4u L=0.18u
C310571635 voutp 0 1p
C49504788 voutn 0 1p
VDD VDD 0 1.8
