M671304192 N003 vip N005 0 nch W=2u L=0.18u
M802058160 N004 vin N005 0 nch W=2u L=0.18u
M433878823 voutn vb3 N003 0 nch W=1u L=0.18u
M671714614 voutp vb3 N004 0 nch W=1u L=0.18u
M781722589 N005 vtail 0 0 nch W=1u L=0.5u
M618323319 voutn vb2 N001 VDD pch W=2u L=0.18u
M178340912 voutp vb2 N002 VDD pch W=2u L=0.18u
M519822234 N001 vb1 VDD VDD pch W=4u L=0.18u
M34822847 N002 vb1 VDD VDD pch W=4u L=0.18u
C579865123 voutp 0 1p
C592675893 voutn 0 1p
VDD VDD 0 1.8
