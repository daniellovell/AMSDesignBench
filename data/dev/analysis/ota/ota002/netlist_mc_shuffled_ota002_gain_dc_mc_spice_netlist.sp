M342468162 N003 vip N005 0 nch W=2u L=0.18u
M515768891 N004 vin N005 0 nch W=2u L=0.18u
M847715480 voutn vb3 N003 0 nch W=1u L=0.18u
M350918676 voutp vb3 N004 0 nch W=1u L=0.18u
M92369559 N005 vtail 0 0 nch W=1u L=0.5u
M480655515 voutn vb2 N001 VDD pch W=2u L=0.18u
M33012497 voutp vb2 N002 VDD pch W=2u L=0.18u
M956481047 N001 vb1 VDD VDD pch W=4u L=0.18u
M327517990 N002 vb1 VDD VDD pch W=4u L=0.18u
C749707931 voutp 0 1p
C704444129 voutn 0 1p
VDD VDD 0 1.8
