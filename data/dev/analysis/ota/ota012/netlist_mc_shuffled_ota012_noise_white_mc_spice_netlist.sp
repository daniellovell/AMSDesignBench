M90474060 N004 vinn N006 VDD PMOS l=0.18u w=4u
M822019822 N004 vinp N005 VDD PMOS l=0.18u w=4u
M646086509 VDD vb1 N002 VDD PMOS l=0.18u w=4u
M11399470 VDD N001 N001 VDD PMOS l=0.18u w=4u
M153526627 VDD N001 N003 VDD PMOS l=0.18u w=4u
M140189961 N001 vb4 vb4 VDD PMOS l=0.18u w=4u
M191993111 N003 vb4 vout VDD PMOS l=0.18u w=4u
M966542093 vout vb3 N005 0 NMOS l=0.18u w=2u
M576360288 N005 vb2 0 0 NMOS l=0.18u w=2u
M6671750 vb4 vb3 N006 0 NMOS l=0.18u w=2u
M976994140 N006 vb2 0 0 NMOS l=0.18u w=2u
VDD VDD 0 1.8
C106179620 vout 0 1p
M886876027 N002 vb5 N004 VDD PMOS l=0.18u w=4u
