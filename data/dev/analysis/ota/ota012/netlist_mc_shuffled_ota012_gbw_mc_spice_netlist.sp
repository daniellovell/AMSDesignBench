M133515914 N004 vinn N006 VDD PMOS l=0.18u w=4u
M788263334 N004 vinp N005 VDD PMOS l=0.18u w=4u
M724169386 VDD vb1 N002 VDD PMOS l=0.18u w=4u
M91192183 VDD N001 N001 VDD PMOS l=0.18u w=4u
M172066911 VDD N001 N003 VDD PMOS l=0.18u w=4u
M706224959 N001 vb4 vb4 VDD PMOS l=0.18u w=4u
M10696341 N003 vb4 vout VDD PMOS l=0.18u w=4u
M357810686 vout vb3 N005 0 NMOS l=0.18u w=2u
M628664365 N005 vb2 0 0 NMOS l=0.18u w=2u
M282256521 vb4 vb3 N006 0 NMOS l=0.18u w=2u
M904215486 N006 vb2 0 0 NMOS l=0.18u w=2u
VDD VDD 0 1.8
C809766424 vout 0 1p
M725607790 N002 vb5 N004 VDD PMOS l=0.18u w=4u
