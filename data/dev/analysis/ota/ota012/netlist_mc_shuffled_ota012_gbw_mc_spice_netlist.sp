M688957551 N004 vinn N006 VDD PMOS l=0.18u w=4u
M513476174 N004 vinp N005 VDD PMOS l=0.18u w=4u
M184085162 VDD vb1 N002 VDD PMOS l=0.18u w=4u
M299788702 VDD N001 N001 VDD PMOS l=0.18u w=4u
M635589299 VDD N001 N003 VDD PMOS l=0.18u w=4u
M87202368 N001 vb4 vb4 VDD PMOS l=0.18u w=4u
M563947981 N003 vb4 vout VDD PMOS l=0.18u w=4u
M506707971 vout vb3 N005 0 NMOS l=0.18u w=2u
M976634858 N005 vb2 0 0 NMOS l=0.18u w=2u
M517924278 vb4 vb3 N006 0 NMOS l=0.18u w=2u
M828431104 N006 vb2 0 0 NMOS l=0.18u w=2u
VDD VDD 0 1.8
C565353393 vout 0 1p
M560869410 N002 vb5 N004 VDD PMOS l=0.18u w=4u
