M654754644 N004 vinn N006 VDD PMOS l=0.18u w=4u
M220058841 N004 vinp N005 VDD PMOS l=0.18u w=4u
M137663118 VDD vb1 N002 VDD PMOS l=0.18u w=4u
M43908390 VDD N001 N001 VDD PMOS l=0.18u w=4u
M667314203 VDD N001 N003 VDD PMOS l=0.18u w=4u
M55165236 N001 vb4 vb4 VDD PMOS l=0.18u w=4u
M281196706 N003 vb4 vout VDD PMOS l=0.18u w=4u
M829004863 vout vb3 N005 0 NMOS l=0.18u w=2u
M8325885 N005 vb2 0 0 NMOS l=0.18u w=2u
M688364026 vb4 vb3 N006 0 NMOS l=0.18u w=2u
M933686160 N006 vb2 0 0 NMOS l=0.18u w=2u
VDD VDD 0 1.8
C836282987 vout 0 1p
M838687814 N002 vb5 N004 VDD PMOS l=0.18u w=4u
