M475632713 N004 vinn N006 VDD PMOS l=0.18u w=4u
M980176659 N004 vinp N005 VDD PMOS l=0.18u w=4u
M176258369 VDD vb1 N002 VDD PMOS l=0.18u w=4u
M171343235 VDD N001 N001 VDD PMOS l=0.18u w=4u
M529504062 VDD N001 N003 VDD PMOS l=0.18u w=4u
M70929287 N001 vb4 vb4 VDD PMOS l=0.18u w=4u
M122031988 N003 vb4 vout VDD PMOS l=0.18u w=4u
M881647162 vout vb3 N005 0 NMOS l=0.18u w=2u
M11437987 N005 vb2 0 0 NMOS l=0.18u w=2u
M432533407 vb4 vb3 N006 0 NMOS l=0.18u w=2u
M732974386 N006 vb2 0 0 NMOS l=0.18u w=2u
VDD VDD 0 1.8
C434829369 vout 0 1p
M971610576 N002 vb5 N004 VDD PMOS l=0.18u w=4u
