M79097245 N004 vinn N006 VDD PMOS l=0.18u w=4u
M833397676 N004 vinp N005 VDD PMOS l=0.18u w=4u
M975830605 VDD vb1 N002 VDD PMOS l=0.18u w=4u
M118364758 VDD N001 N001 VDD PMOS l=0.18u w=4u
M891813113 VDD N001 N003 VDD PMOS l=0.18u w=4u
M661015385 N001 vb4 vb4 VDD PMOS l=0.18u w=4u
M392160461 N003 vb4 vout VDD PMOS l=0.18u w=4u
M666044470 vout vb3 N005 0 NMOS l=0.18u w=2u
M749593650 N005 vb2 0 0 NMOS l=0.18u w=2u
M581731218 vb4 vb3 N006 0 NMOS l=0.18u w=2u
M115381542 N006 vb2 0 0 NMOS l=0.18u w=2u
VDD VDD 0 1.8
C170577215 vout 0 1p
M549438617 N002 vb5 N004 VDD PMOS l=0.18u w=4u
