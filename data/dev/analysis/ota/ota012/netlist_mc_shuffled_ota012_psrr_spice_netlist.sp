M653654038 N004 vinn N006 VDD PMOS l=0.18u w=4u
M84772802 N004 vinp N005 VDD PMOS l=0.18u w=4u
M344386338 VDD vb1 N002 VDD PMOS l=0.18u w=4u
M569267395 VDD N001 N001 VDD PMOS l=0.18u w=4u
M87872534 VDD N001 N003 VDD PMOS l=0.18u w=4u
M839135794 N001 vb4 vb4 VDD PMOS l=0.18u w=4u
M959267526 N003 vb4 vout VDD PMOS l=0.18u w=4u
M456981656 vout vb3 N005 0 NMOS l=0.18u w=2u
M122076298 N005 vb2 0 0 NMOS l=0.18u w=2u
M315200463 vb4 vb3 N006 0 NMOS l=0.18u w=2u
M407270800 N006 vb2 0 0 NMOS l=0.18u w=2u
VDD VDD 0 1.8
C512201356 vout 0 1p
M619587719 N002 vb5 N004 VDD PMOS l=0.18u w=4u
