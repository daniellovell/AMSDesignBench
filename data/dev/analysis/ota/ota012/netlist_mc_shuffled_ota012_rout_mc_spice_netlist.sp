M508511655 N004 vinn N006 VDD PMOS l=0.18u w=4u
M765306081 N004 vinp N005 VDD PMOS l=0.18u w=4u
M16811953 VDD vb1 N002 VDD PMOS l=0.18u w=4u
M455589144 VDD N001 N001 VDD PMOS l=0.18u w=4u
M293260138 VDD N001 N003 VDD PMOS l=0.18u w=4u
M981814811 N001 vb4 vb4 VDD PMOS l=0.18u w=4u
M662150565 N003 vb4 vout VDD PMOS l=0.18u w=4u
M765712363 vout vb3 N005 0 NMOS l=0.18u w=2u
M565902114 N005 vb2 0 0 NMOS l=0.18u w=2u
M468857119 vb4 vb3 N006 0 NMOS l=0.18u w=2u
M151757649 N006 vb2 0 0 NMOS l=0.18u w=2u
VDD VDD 0 1.8
C209555625 vout 0 1p
M804564740 N002 vb5 N004 VDD PMOS l=0.18u w=4u
