M857595187 N004 vinn N006 VDD PMOS l=0.18u w=4u
M463276305 N004 vinp N005 VDD PMOS l=0.18u w=4u
M373567169 VDD vb1 N002 VDD PMOS l=0.18u w=4u
M361463807 VDD N001 N001 VDD PMOS l=0.18u w=4u
M439129362 VDD N001 N003 VDD PMOS l=0.18u w=4u
M958751973 N001 vb4 vb4 VDD PMOS l=0.18u w=4u
M177226863 N003 vb4 vout VDD PMOS l=0.18u w=4u
M903977726 vout vb3 N005 0 NMOS l=0.18u w=2u
M125611508 N005 vb2 0 0 NMOS l=0.18u w=2u
M83669656 vb4 vb3 N006 0 NMOS l=0.18u w=2u
M195941444 N006 vb2 0 0 NMOS l=0.18u w=2u
VDD VDD 0 1.8
C603605873 vout 0 1p
M697803171 N002 vb5 N004 VDD PMOS l=0.18u w=4u
