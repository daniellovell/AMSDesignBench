M72081804 N004 vinn N006 VDD PMOS l=0.18u w=4u
M547908653 N004 vinp N005 VDD PMOS l=0.18u w=4u
M445717508 VDD vb1 N002 VDD PMOS l=0.18u w=4u
M519257929 VDD N001 N001 VDD PMOS l=0.18u w=4u
M943855118 VDD N001 N003 VDD PMOS l=0.18u w=4u
M720540221 N001 vb4 vb4 VDD PMOS l=0.18u w=4u
M568940402 N003 vb4 vout VDD PMOS l=0.18u w=4u
M740460409 vout vb3 N005 0 NMOS l=0.18u w=2u
M253271721 N005 vb2 0 0 NMOS l=0.18u w=2u
M794324880 vb4 vb3 N006 0 NMOS l=0.18u w=2u
M197308299 N006 vb2 0 0 NMOS l=0.18u w=2u
VDD VDD 0 1.8
C326099656 vout 0 1p
M492968147 N002 vb5 N004 VDD PMOS l=0.18u w=4u
