M898103374 N004 vinn N006 VDD PMOS l=0.18u w=4u
M873214981 N004 vinp N005 VDD PMOS l=0.18u w=4u
M13900541 VDD vb1 N002 VDD PMOS l=0.18u w=4u
M695528023 VDD N001 N001 VDD PMOS l=0.18u w=4u
M806256817 VDD N001 N003 VDD PMOS l=0.18u w=4u
M800016206 N001 vb4 vb4 VDD PMOS l=0.18u w=4u
M807444348 N003 vb4 vout VDD PMOS l=0.18u w=4u
M500954907 vout vb3 N005 0 NMOS l=0.18u w=2u
M635529408 N005 vb2 0 0 NMOS l=0.18u w=2u
M961718352 vb4 vb3 N006 0 NMOS l=0.18u w=2u
M363777340 N006 vb2 0 0 NMOS l=0.18u w=2u
VDD VDD 0 1.8
C650004454 vout 0 1p
M611151091 N002 vb5 N004 VDD PMOS l=0.18u w=4u
