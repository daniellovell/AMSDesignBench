M795319532 N004 vinn N006 VDD PMOS l=0.18u w=4u
M132270292 N004 vinp N005 VDD PMOS l=0.18u w=4u
M856961386 VDD vb1 N002 VDD PMOS l=0.18u w=4u
M886133819 VDD N001 N001 VDD PMOS l=0.18u w=4u
M364241153 VDD N001 N003 VDD PMOS l=0.18u w=4u
M231300502 N001 vb4 vb4 VDD PMOS l=0.18u w=4u
M964420997 N003 vb4 vout VDD PMOS l=0.18u w=4u
M9535643 vout vb3 N005 0 NMOS l=0.18u w=2u
M506295746 N005 vb2 0 0 NMOS l=0.18u w=2u
M423061433 vb4 vb3 N006 0 NMOS l=0.18u w=2u
M798107224 N006 vb2 0 0 NMOS l=0.18u w=2u
VDD VDD 0 1.8
C388026147 vout 0 1p
M119231231 N002 vb5 N004 VDD PMOS l=0.18u w=4u
