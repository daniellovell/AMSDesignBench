M871173052 N004 vinn N006 VDD PMOS l=0.18u w=4u
M137429732 N004 vinp N005 VDD PMOS l=0.18u w=4u
M12953560 VDD vb1 N002 VDD PMOS l=0.18u w=4u
M903993464 VDD N001 N001 VDD PMOS l=0.18u w=4u
M690812978 VDD N001 N003 VDD PMOS l=0.18u w=4u
M343884329 N001 vb4 vb4 VDD PMOS l=0.18u w=4u
M530967031 N003 vb4 vout VDD PMOS l=0.18u w=4u
M825607572 vout vb3 N005 0 NMOS l=0.18u w=2u
M922182428 N005 vb2 0 0 NMOS l=0.18u w=2u
M888150721 vb4 vb3 N006 0 NMOS l=0.18u w=2u
M921134226 N006 vb2 0 0 NMOS l=0.18u w=2u
VDD VDD 0 1.8
C43737944 vout 0 1p
M764889500 N002 vb5 N004 VDD PMOS l=0.18u w=4u
