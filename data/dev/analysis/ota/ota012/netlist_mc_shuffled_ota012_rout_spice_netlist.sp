M563242588 N004 vinn N006 VDD PMOS l=0.18u w=4u
M589306642 N004 vinp N005 VDD PMOS l=0.18u w=4u
M485678352 VDD vb1 N002 VDD PMOS l=0.18u w=4u
M550083491 VDD N001 N001 VDD PMOS l=0.18u w=4u
M507108766 VDD N001 N003 VDD PMOS l=0.18u w=4u
M749259764 N001 vb4 vb4 VDD PMOS l=0.18u w=4u
M901169627 N003 vb4 vout VDD PMOS l=0.18u w=4u
M946664306 vout vb3 N005 0 NMOS l=0.18u w=2u
M681118046 N005 vb2 0 0 NMOS l=0.18u w=2u
M928328612 vb4 vb3 N006 0 NMOS l=0.18u w=2u
M312530675 N006 vb2 0 0 NMOS l=0.18u w=2u
VDD VDD 0 1.8
C300877050 vout 0 1p
M834765454 N002 vb5 N004 VDD PMOS l=0.18u w=4u
