M754445780 N004 vinn N006 VDD PMOS l=0.18u w=4u
M708162999 N004 vinp N005 VDD PMOS l=0.18u w=4u
M271189083 VDD vb1 N002 VDD PMOS l=0.18u w=4u
M349993541 VDD N001 N001 VDD PMOS l=0.18u w=4u
M749565064 VDD N001 N003 VDD PMOS l=0.18u w=4u
M947700714 N001 vb4 vb4 VDD PMOS l=0.18u w=4u
M980845832 N003 vb4 vout VDD PMOS l=0.18u w=4u
M461502246 vout vb3 N005 0 NMOS l=0.18u w=2u
M314019787 N005 vb2 0 0 NMOS l=0.18u w=2u
M454175550 vb4 vb3 N006 0 NMOS l=0.18u w=2u
M883398175 N006 vb2 0 0 NMOS l=0.18u w=2u
VDD VDD 0 1.8
C998593714 vout 0 1p
M463322892 N002 vb5 N004 VDD PMOS l=0.18u w=4u
