M369186920 N004 vinn N006 VDD PMOS l=0.18u w=4u
M126354921 N004 vinp N005 VDD PMOS l=0.18u w=4u
M8009309 VDD vb1 N002 VDD PMOS l=0.18u w=4u
M922348153 VDD N001 N001 VDD PMOS l=0.18u w=4u
M76244010 VDD N001 N003 VDD PMOS l=0.18u w=4u
M570294017 N001 vb4 vb4 VDD PMOS l=0.18u w=4u
M501911660 N003 vb4 vout VDD PMOS l=0.18u w=4u
M655835568 vout vb3 N005 0 NMOS l=0.18u w=2u
M996678907 N005 vb2 0 0 NMOS l=0.18u w=2u
M35613106 vb4 vb3 N006 0 NMOS l=0.18u w=2u
M910189734 N006 vb2 0 0 NMOS l=0.18u w=2u
VDD VDD 0 1.8
C914146266 vout 0 1p
M424093261 N002 vb5 N004 VDD PMOS l=0.18u w=4u
