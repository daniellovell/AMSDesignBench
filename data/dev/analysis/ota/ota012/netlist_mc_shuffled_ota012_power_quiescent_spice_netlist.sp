M529470099 N004 vinn N006 VDD PMOS l=0.18u w=4u
M55363723 N004 vinp N005 VDD PMOS l=0.18u w=4u
M484641290 VDD vb1 N002 VDD PMOS l=0.18u w=4u
M889446155 VDD N001 N001 VDD PMOS l=0.18u w=4u
M597925530 VDD N001 N003 VDD PMOS l=0.18u w=4u
M800115978 N001 vb4 vb4 VDD PMOS l=0.18u w=4u
M460777009 N003 vb4 vout VDD PMOS l=0.18u w=4u
M86051916 vout vb3 N005 0 NMOS l=0.18u w=2u
M746435733 N005 vb2 0 0 NMOS l=0.18u w=2u
M227260128 vb4 vb3 N006 0 NMOS l=0.18u w=2u
M242756313 N006 vb2 0 0 NMOS l=0.18u w=2u
VDD VDD 0 1.8
C93870957 vout 0 1p
M145806333 N002 vb5 N004 VDD PMOS l=0.18u w=4u
