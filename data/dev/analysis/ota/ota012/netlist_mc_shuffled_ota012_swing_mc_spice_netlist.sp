M351078752 N004 vinn N006 VDD PMOS l=0.18u w=4u
M590005682 N004 vinp N005 VDD PMOS l=0.18u w=4u
M432171321 VDD vb1 N002 VDD PMOS l=0.18u w=4u
M115570491 VDD N001 N001 VDD PMOS l=0.18u w=4u
M879199447 VDD N001 N003 VDD PMOS l=0.18u w=4u
M375990068 N001 vb4 vb4 VDD PMOS l=0.18u w=4u
M363312272 N003 vb4 vout VDD PMOS l=0.18u w=4u
M154775593 vout vb3 N005 0 NMOS l=0.18u w=2u
M819798683 N005 vb2 0 0 NMOS l=0.18u w=2u
M881194145 vb4 vb3 N006 0 NMOS l=0.18u w=2u
M105404191 N006 vb2 0 0 NMOS l=0.18u w=2u
VDD VDD 0 1.8
C973038775 vout 0 1p
M997765345 N002 vb5 N004 VDD PMOS l=0.18u w=4u
