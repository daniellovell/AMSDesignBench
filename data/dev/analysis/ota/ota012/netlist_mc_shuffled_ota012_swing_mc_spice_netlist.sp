M526615440 N004 vinn N006 VDD PMOS l=0.18u w=4u
M826173234 N004 vinp N005 VDD PMOS l=0.18u w=4u
M141076519 VDD vb1 N002 VDD PMOS l=0.18u w=4u
M260207306 VDD N001 N001 VDD PMOS l=0.18u w=4u
M968167559 VDD N001 N003 VDD PMOS l=0.18u w=4u
M910861392 N001 vb4 vb4 VDD PMOS l=0.18u w=4u
M729296585 N003 vb4 vout VDD PMOS l=0.18u w=4u
M656029427 vout vb3 N005 0 NMOS l=0.18u w=2u
M394808906 N005 vb2 0 0 NMOS l=0.18u w=2u
M726204640 vb4 vb3 N006 0 NMOS l=0.18u w=2u
M13700094 N006 vb2 0 0 NMOS l=0.18u w=2u
VDD VDD 0 1.8
C924162553 vout 0 1p
M305535949 N002 vb5 N004 VDD PMOS l=0.18u w=4u
