C781303093 vop 0 1p
M818535809 N002 N003 vop VDD PMOS l=0.18u w=4u
M828883474 VDD N001 N002 VDD PMOS l=0.18u w=4u
M922857691 VDD N001 N001 VDD PMOS l=0.18u w=4u
M583866022 N001 N003 N003 VDD PMOS l=0.18u w=4u
M578837740 N003 vb3 N004 0 NMOS l=0.18u w=2u
M189219289 vop vb3 N005 0 NMOS l=0.18u w=2u
M866217493 N005 vin N006 0 NMOS l=0.18u w=2u
M911029302 N004 vip N006 0 NMOS l=0.18u w=2u
M819958638 N006 vtail 0 0 NMOS l=0.18u w=2u
VDD VDD 0 1.8
