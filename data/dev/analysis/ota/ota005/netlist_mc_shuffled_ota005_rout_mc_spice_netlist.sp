C953406361 vop 0 1p
M133154171 N002 N003 vop VDD PMOS l=0.18u w=4u
M131578072 VDD N001 N002 VDD PMOS l=0.18u w=4u
M460014413 VDD N001 N001 VDD PMOS l=0.18u w=4u
M138647373 N001 N003 N003 VDD PMOS l=0.18u w=4u
M524177560 N003 vb3 N004 0 NMOS l=0.18u w=2u
M437821737 vop vb3 N005 0 NMOS l=0.18u w=2u
M704433480 N005 vin N006 0 NMOS l=0.18u w=2u
M801519417 N004 vip N006 0 NMOS l=0.18u w=2u
M280395811 N006 vtail 0 0 NMOS l=0.18u w=2u
VDD VDD 0 1.8
