C887991525 vop 0 1p
M399695752 N002 N003 vop VDD PMOS l=0.18u w=4u
M559789807 VDD N001 N002 VDD PMOS l=0.18u w=4u
M133423380 VDD N001 N001 VDD PMOS l=0.18u w=4u
M463021406 N001 N003 N003 VDD PMOS l=0.18u w=4u
M250979538 N003 vb3 N004 0 NMOS l=0.18u w=2u
M379594521 vop vb3 N005 0 NMOS l=0.18u w=2u
M733184371 N005 vin N006 0 NMOS l=0.18u w=2u
M165040753 N004 vip N006 0 NMOS l=0.18u w=2u
M807665770 N006 vtail 0 0 NMOS l=0.18u w=2u
VDD VDD 0 1.8
