C236217305 vop 0 1p
M274045674 N002 N003 vop VDD PMOS l=0.18u w=4u
M250125670 VDD N001 N002 VDD PMOS l=0.18u w=4u
M878637411 VDD N001 N001 VDD PMOS l=0.18u w=4u
M966801284 N001 N003 N003 VDD PMOS l=0.18u w=4u
M383166952 N003 vb3 N004 0 NMOS l=0.18u w=2u
M694250195 vop vb3 N005 0 NMOS l=0.18u w=2u
M519917959 N005 vin N006 0 NMOS l=0.18u w=2u
M970265745 N004 vip N006 0 NMOS l=0.18u w=2u
M237011529 N006 vtail 0 0 NMOS l=0.18u w=2u
VDD VDD 0 1.8
