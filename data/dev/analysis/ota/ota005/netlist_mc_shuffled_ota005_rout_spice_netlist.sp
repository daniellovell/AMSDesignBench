C253899473 vop 0 1p
M275450650 N002 N003 vop VDD PMOS l=0.18u w=4u
M968378669 VDD N001 N002 VDD PMOS l=0.18u w=4u
M89624735 VDD N001 N001 VDD PMOS l=0.18u w=4u
M505532478 N001 N003 N003 VDD PMOS l=0.18u w=4u
M818463303 N003 vb3 N004 0 NMOS l=0.18u w=2u
M89826349 vop vb3 N005 0 NMOS l=0.18u w=2u
M710528841 N005 vin N006 0 NMOS l=0.18u w=2u
M514025782 N004 vip N006 0 NMOS l=0.18u w=2u
M515597609 N006 vtail 0 0 NMOS l=0.18u w=2u
VDD VDD 0 1.8
