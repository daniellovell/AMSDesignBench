C168563571 vop 0 1p
M346371754 N002 N003 vop VDD PMOS l=0.18u w=4u
M239818887 VDD N001 N002 VDD PMOS l=0.18u w=4u
M15832312 VDD N001 N001 VDD PMOS l=0.18u w=4u
M945358679 N001 N003 N003 VDD PMOS l=0.18u w=4u
M927687341 N003 vb3 N004 0 NMOS l=0.18u w=2u
M534779179 vop vb3 N005 0 NMOS l=0.18u w=2u
M101158723 N005 vin N006 0 NMOS l=0.18u w=2u
M449098122 N004 vip N006 0 NMOS l=0.18u w=2u
M402676934 N006 vtail 0 0 NMOS l=0.18u w=2u
VDD VDD 0 1.8
