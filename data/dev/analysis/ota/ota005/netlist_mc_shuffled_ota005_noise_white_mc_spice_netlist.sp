C923297522 vop 0 1p
M310575691 N002 N003 vop VDD PMOS l=0.18u w=4u
M39565838 VDD N001 N002 VDD PMOS l=0.18u w=4u
M464923582 VDD N001 N001 VDD PMOS l=0.18u w=4u
M966759508 N001 N003 N003 VDD PMOS l=0.18u w=4u
M338672118 N003 vb3 N004 0 NMOS l=0.18u w=2u
M742745558 vop vb3 N005 0 NMOS l=0.18u w=2u
M827739049 N005 vin N006 0 NMOS l=0.18u w=2u
M404664600 N004 vip N006 0 NMOS l=0.18u w=2u
M422115196 N006 vtail 0 0 NMOS l=0.18u w=2u
VDD VDD 0 1.8
