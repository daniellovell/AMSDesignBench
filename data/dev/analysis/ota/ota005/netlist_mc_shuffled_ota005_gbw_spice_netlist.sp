C586078095 vop 0 1p
M872419100 N002 N003 vop VDD PMOS l=0.18u w=4u
M101277700 VDD N001 N002 VDD PMOS l=0.18u w=4u
M933065408 VDD N001 N001 VDD PMOS l=0.18u w=4u
M140052700 N001 N003 N003 VDD PMOS l=0.18u w=4u
M909960784 N003 vb3 N004 0 NMOS l=0.18u w=2u
M350105684 vop vb3 N005 0 NMOS l=0.18u w=2u
M618042028 N005 vin N006 0 NMOS l=0.18u w=2u
M612268481 N004 vip N006 0 NMOS l=0.18u w=2u
M757962449 N006 vtail 0 0 NMOS l=0.18u w=2u
VDD VDD 0 1.8
