C3303642 vop 0 1p
M801128900 N002 N003 vop VDD PMOS l=0.18u w=4u
M502423170 VDD N001 N002 VDD PMOS l=0.18u w=4u
M456939695 VDD N001 N001 VDD PMOS l=0.18u w=4u
M714067510 N001 N003 N003 VDD PMOS l=0.18u w=4u
M356084557 N003 vb3 N004 0 NMOS l=0.18u w=2u
M115382569 vop vb3 N005 0 NMOS l=0.18u w=2u
M481068750 N005 vin N006 0 NMOS l=0.18u w=2u
M842527478 N004 vip N006 0 NMOS l=0.18u w=2u
M614701653 N006 vtail 0 0 NMOS l=0.18u w=2u
VDD VDD 0 1.8
