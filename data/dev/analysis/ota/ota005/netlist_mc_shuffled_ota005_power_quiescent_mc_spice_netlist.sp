C790988034 vop 0 1p
M756236081 N002 N003 vop VDD PMOS l=0.18u w=4u
M106070289 VDD N001 N002 VDD PMOS l=0.18u w=4u
M260654398 VDD N001 N001 VDD PMOS l=0.18u w=4u
M52984730 N001 N003 N003 VDD PMOS l=0.18u w=4u
M309276205 N003 vb3 N004 0 NMOS l=0.18u w=2u
M708599976 vop vb3 N005 0 NMOS l=0.18u w=2u
M354033403 N005 vin N006 0 NMOS l=0.18u w=2u
M138839436 N004 vip N006 0 NMOS l=0.18u w=2u
M223345618 N006 vtail 0 0 NMOS l=0.18u w=2u
VDD VDD 0 1.8
