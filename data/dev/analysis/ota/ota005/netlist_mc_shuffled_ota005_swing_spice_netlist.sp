C983875103 vop 0 1p
M484755242 N002 N003 vop VDD PMOS l=0.18u w=4u
M125761653 VDD N001 N002 VDD PMOS l=0.18u w=4u
M61115357 VDD N001 N001 VDD PMOS l=0.18u w=4u
M906373922 N001 N003 N003 VDD PMOS l=0.18u w=4u
M691366150 N003 vb3 N004 0 NMOS l=0.18u w=2u
M874850148 vop vb3 N005 0 NMOS l=0.18u w=2u
M657620281 N005 vin N006 0 NMOS l=0.18u w=2u
M231371283 N004 vip N006 0 NMOS l=0.18u w=2u
M662421204 N006 vtail 0 0 NMOS l=0.18u w=2u
VDD VDD 0 1.8
