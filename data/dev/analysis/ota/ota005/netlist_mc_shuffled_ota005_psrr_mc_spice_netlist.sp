C486920171 vop 0 1p
M415477759 N002 N003 vop VDD PMOS l=0.18u w=4u
M332693928 VDD N001 N002 VDD PMOS l=0.18u w=4u
M409430649 VDD N001 N001 VDD PMOS l=0.18u w=4u
M41421779 N001 N003 N003 VDD PMOS l=0.18u w=4u
M608127707 N003 vb3 N004 0 NMOS l=0.18u w=2u
M163806888 vop vb3 N005 0 NMOS l=0.18u w=2u
M963721461 N005 vin N006 0 NMOS l=0.18u w=2u
M230399341 N004 vip N006 0 NMOS l=0.18u w=2u
M50115804 N006 vtail 0 0 NMOS l=0.18u w=2u
VDD VDD 0 1.8
