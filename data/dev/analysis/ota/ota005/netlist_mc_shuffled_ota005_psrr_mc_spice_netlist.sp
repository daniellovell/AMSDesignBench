C67416500 vop 0 1p
M965965948 N002 N003 vop VDD PMOS l=0.18u w=4u
M643758192 VDD N001 N002 VDD PMOS l=0.18u w=4u
M951546772 VDD N001 N001 VDD PMOS l=0.18u w=4u
M408079456 N001 N003 N003 VDD PMOS l=0.18u w=4u
M294450630 N003 vb3 N004 0 NMOS l=0.18u w=2u
M367481394 vop vb3 N005 0 NMOS l=0.18u w=2u
M978121434 N005 vin N006 0 NMOS l=0.18u w=2u
M928890987 N004 vip N006 0 NMOS l=0.18u w=2u
M683106267 N006 vtail 0 0 NMOS l=0.18u w=2u
VDD VDD 0 1.8
