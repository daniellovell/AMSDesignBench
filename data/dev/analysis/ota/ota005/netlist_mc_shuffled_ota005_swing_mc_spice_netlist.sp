C516950563 vop 0 1p
M373019175 N002 N003 vop VDD PMOS l=0.18u w=4u
M682456571 VDD N001 N002 VDD PMOS l=0.18u w=4u
M84367490 VDD N001 N001 VDD PMOS l=0.18u w=4u
M428123319 N001 N003 N003 VDD PMOS l=0.18u w=4u
M931409564 N003 vb3 N004 0 NMOS l=0.18u w=2u
M659468740 vop vb3 N005 0 NMOS l=0.18u w=2u
M225134026 N005 vin N006 0 NMOS l=0.18u w=2u
M436512329 N004 vip N006 0 NMOS l=0.18u w=2u
M515111029 N006 vtail 0 0 NMOS l=0.18u w=2u
VDD VDD 0 1.8
