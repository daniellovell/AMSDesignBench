C98084549 vop 0 1p
M588664890 N002 N003 vop VDD PMOS l=0.18u w=4u
M959943625 VDD N001 N002 VDD PMOS l=0.18u w=4u
M959706513 VDD N001 N001 VDD PMOS l=0.18u w=4u
M770728567 N001 N003 N003 VDD PMOS l=0.18u w=4u
M209691110 N003 vb3 N004 0 NMOS l=0.18u w=2u
M306048363 vop vb3 N005 0 NMOS l=0.18u w=2u
M205574370 N005 vin N006 0 NMOS l=0.18u w=2u
M596084716 N004 vip N006 0 NMOS l=0.18u w=2u
M134028817 N006 vtail 0 0 NMOS l=0.18u w=2u
VDD VDD 0 1.8
