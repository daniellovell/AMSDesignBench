C2085420 vop 0 1p
M439662417 N002 N003 vop VDD PMOS l=0.18u w=4u
M985794999 VDD N001 N002 VDD PMOS l=0.18u w=4u
M186265248 VDD N001 N001 VDD PMOS l=0.18u w=4u
M163422858 N001 N003 N003 VDD PMOS l=0.18u w=4u
M373662211 N003 vb3 N004 0 NMOS l=0.18u w=2u
M691001451 vop vb3 N005 0 NMOS l=0.18u w=2u
M89802414 N005 vin N006 0 NMOS l=0.18u w=2u
M355212057 N004 vip N006 0 NMOS l=0.18u w=2u
M862150514 N006 vtail 0 0 NMOS l=0.18u w=2u
VDD VDD 0 1.8
