C793314946 vop 0 1p
M216481246 N002 N003 vop VDD PMOS l=0.18u w=4u
M87017519 VDD N001 N002 VDD PMOS l=0.18u w=4u
M443687778 VDD N001 N001 VDD PMOS l=0.18u w=4u
M627006323 N001 N003 N003 VDD PMOS l=0.18u w=4u
M397939770 N003 vb3 N004 0 NMOS l=0.18u w=2u
M721636658 vop vb3 N005 0 NMOS l=0.18u w=2u
M71884695 N005 vin N006 0 NMOS l=0.18u w=2u
M226528584 N004 vip N006 0 NMOS l=0.18u w=2u
M992728144 N006 vtail 0 0 NMOS l=0.18u w=2u
VDD VDD 0 1.8
