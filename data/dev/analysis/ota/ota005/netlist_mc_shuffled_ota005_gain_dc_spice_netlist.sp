C68749447 vop 0 1p
M747193090 N002 N003 vop VDD PMOS l=0.18u w=4u
M569393152 VDD N001 N002 VDD PMOS l=0.18u w=4u
M693170141 VDD N001 N001 VDD PMOS l=0.18u w=4u
M156416651 N001 N003 N003 VDD PMOS l=0.18u w=4u
M240552907 N003 vb3 N004 0 NMOS l=0.18u w=2u
M806329151 vop vb3 N005 0 NMOS l=0.18u w=2u
M785913504 N005 vin N006 0 NMOS l=0.18u w=2u
M301534200 N004 vip N006 0 NMOS l=0.18u w=2u
M106797157 N006 vtail 0 0 NMOS l=0.18u w=2u
VDD VDD 0 1.8
