C621915668 vop 0 1p
M812243056 N002 N003 vop VDD PMOS l=0.18u w=4u
M739166179 VDD N001 N002 VDD PMOS l=0.18u w=4u
M193536591 VDD N001 N001 VDD PMOS l=0.18u w=4u
M806252189 N001 N003 N003 VDD PMOS l=0.18u w=4u
M386736296 N003 vb3 N004 0 NMOS l=0.18u w=2u
M326015940 vop vb3 N005 0 NMOS l=0.18u w=2u
M352577618 N005 vin N006 0 NMOS l=0.18u w=2u
M571392820 N004 vip N006 0 NMOS l=0.18u w=2u
M598831741 N006 vtail 0 0 NMOS l=0.18u w=2u
VDD VDD 0 1.8
