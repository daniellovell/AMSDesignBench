C882144669 vop 0 1p
M359633081 N002 N003 vop VDD PMOS l=0.18u w=4u
M985730910 VDD N001 N002 VDD PMOS l=0.18u w=4u
M819526668 VDD N001 N001 VDD PMOS l=0.18u w=4u
M822897949 N001 N003 N003 VDD PMOS l=0.18u w=4u
M297637621 N003 vb3 N004 0 NMOS l=0.18u w=2u
M834231962 vop vb3 N005 0 NMOS l=0.18u w=2u
M870810405 N005 vin N006 0 NMOS l=0.18u w=2u
M119209820 N004 vip N006 0 NMOS l=0.18u w=2u
M571226324 N006 vtail 0 0 NMOS l=0.18u w=2u
VDD VDD 0 1.8
