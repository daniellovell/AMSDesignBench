C479400801 vop 0 1p
M289840311 N002 N003 vop VDD PMOS l=0.18u w=4u
M236207606 VDD N001 N002 VDD PMOS l=0.18u w=4u
M530734080 VDD N001 N001 VDD PMOS l=0.18u w=4u
M440077434 N001 N003 N003 VDD PMOS l=0.18u w=4u
M567065951 N003 vb3 N004 0 NMOS l=0.18u w=2u
M913042056 vop vb3 N005 0 NMOS l=0.18u w=2u
M462778396 N005 vin N006 0 NMOS l=0.18u w=2u
M11803710 N004 vip N006 0 NMOS l=0.18u w=2u
M842675995 N006 vtail 0 0 NMOS l=0.18u w=2u
VDD VDD 0 1.8
