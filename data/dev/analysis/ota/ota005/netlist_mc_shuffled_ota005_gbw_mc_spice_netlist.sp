C12598832 vop 0 1p
M604694316 N002 N003 vop VDD PMOS l=0.18u w=4u
M998504524 VDD N001 N002 VDD PMOS l=0.18u w=4u
M927591477 VDD N001 N001 VDD PMOS l=0.18u w=4u
M484889795 N001 N003 N003 VDD PMOS l=0.18u w=4u
M859595184 N003 vb3 N004 0 NMOS l=0.18u w=2u
M60538359 vop vb3 N005 0 NMOS l=0.18u w=2u
M11755954 N005 vin N006 0 NMOS l=0.18u w=2u
M387351620 N004 vip N006 0 NMOS l=0.18u w=2u
M445108392 N006 vtail 0 0 NMOS l=0.18u w=2u
VDD VDD 0 1.8
