M515907859 N002 vinn N006 VDD PMOS l=0.18u w=4u
M873986340 N002 vinp N005 VDD PMOS l=0.18u w=4u
M612621840 VDD vb1 N002 VDD PMOS l=0.18u w=4u
M698224961 VDD N001 N003 VDD PMOS l=0.18u w=4u
M355366601 VDD N001 N004 VDD PMOS l=0.18u w=4u
M168135959 N003 vb4 N001 VDD PMOS l=0.18u w=4u
M809899291 N004 vb4 vout VDD PMOS l=0.18u w=4u
M98360674 vout vb3 N005 0 NMOS l=0.18u w=2u
M322418800 N005 vb2 0 0 NMOS l=0.18u w=2u
M808500687 N001 vb3 N006 0 NMOS l=0.18u w=2u
M118027355 N006 vb2 0 0 NMOS l=0.18u w=2u
VDD VDD 0 1.8
C224735280 vout 0 1p
