M90479406 N002 vinn N006 VDD PMOS l=0.18u w=4u
M71253487 N002 vinp N005 VDD PMOS l=0.18u w=4u
M404339329 VDD vb1 N002 VDD PMOS l=0.18u w=4u
M420724000 VDD N001 N003 VDD PMOS l=0.18u w=4u
M184527353 VDD N001 N004 VDD PMOS l=0.18u w=4u
M82359543 N003 vb4 N001 VDD PMOS l=0.18u w=4u
M329651827 N004 vb4 vout VDD PMOS l=0.18u w=4u
M182090659 vout vb3 N005 0 NMOS l=0.18u w=2u
M742751331 N005 vb2 0 0 NMOS l=0.18u w=2u
M438545950 N001 vb3 N006 0 NMOS l=0.18u w=2u
M667075292 N006 vb2 0 0 NMOS l=0.18u w=2u
VDD VDD 0 1.8
C960213555 vout 0 1p
