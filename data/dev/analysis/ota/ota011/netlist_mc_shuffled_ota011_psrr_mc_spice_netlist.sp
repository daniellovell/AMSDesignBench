M711921080 N002 vinn N006 VDD PMOS l=0.18u w=4u
M471858809 N002 vinp N005 VDD PMOS l=0.18u w=4u
M959332601 VDD vb1 N002 VDD PMOS l=0.18u w=4u
M23906550 VDD N001 N003 VDD PMOS l=0.18u w=4u
M314064506 VDD N001 N004 VDD PMOS l=0.18u w=4u
M214781912 N003 vb4 N001 VDD PMOS l=0.18u w=4u
M163552392 N004 vb4 vout VDD PMOS l=0.18u w=4u
M307045383 vout vb3 N005 0 NMOS l=0.18u w=2u
M858203160 N005 vb2 0 0 NMOS l=0.18u w=2u
M557443525 N001 vb3 N006 0 NMOS l=0.18u w=2u
M621679216 N006 vb2 0 0 NMOS l=0.18u w=2u
VDD VDD 0 1.8
C244684476 vout 0 1p
