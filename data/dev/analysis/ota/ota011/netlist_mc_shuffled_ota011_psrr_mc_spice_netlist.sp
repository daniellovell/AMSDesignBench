M519691937 N002 vinn N006 VDD PMOS l=0.18u w=4u
M627153477 N002 vinp N005 VDD PMOS l=0.18u w=4u
M13133088 VDD vb1 N002 VDD PMOS l=0.18u w=4u
M33916982 VDD N001 N003 VDD PMOS l=0.18u w=4u
M353696808 VDD N001 N004 VDD PMOS l=0.18u w=4u
M194164956 N003 vb4 N001 VDD PMOS l=0.18u w=4u
M913424628 N004 vb4 vout VDD PMOS l=0.18u w=4u
M31413868 vout vb3 N005 0 NMOS l=0.18u w=2u
M199700500 N005 vb2 0 0 NMOS l=0.18u w=2u
M495051944 N001 vb3 N006 0 NMOS l=0.18u w=2u
M604238267 N006 vb2 0 0 NMOS l=0.18u w=2u
VDD VDD 0 1.8
C458191426 vout 0 1p
