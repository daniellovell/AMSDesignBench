M548196421 N002 vinn N006 VDD PMOS l=0.18u w=4u
M335118997 N002 vinp N005 VDD PMOS l=0.18u w=4u
M280188440 VDD vb1 N002 VDD PMOS l=0.18u w=4u
M152043977 VDD N001 N003 VDD PMOS l=0.18u w=4u
M565814227 VDD N001 N004 VDD PMOS l=0.18u w=4u
M651411549 N003 vb4 N001 VDD PMOS l=0.18u w=4u
M331230769 N004 vb4 vout VDD PMOS l=0.18u w=4u
M871638948 vout vb3 N005 0 NMOS l=0.18u w=2u
M352760524 N005 vb2 0 0 NMOS l=0.18u w=2u
M233969466 N001 vb3 N006 0 NMOS l=0.18u w=2u
M255079331 N006 vb2 0 0 NMOS l=0.18u w=2u
VDD VDD 0 1.8
C271841398 vout 0 1p
