M235309828 N002 vinn N006 VDD PMOS l=0.18u w=4u
M701508392 N002 vinp N005 VDD PMOS l=0.18u w=4u
M871077170 VDD vb1 N002 VDD PMOS l=0.18u w=4u
M927829807 VDD N001 N003 VDD PMOS l=0.18u w=4u
M188185026 VDD N001 N004 VDD PMOS l=0.18u w=4u
M984987051 N003 vb4 N001 VDD PMOS l=0.18u w=4u
M258442001 N004 vb4 vout VDD PMOS l=0.18u w=4u
M886629182 vout vb3 N005 0 NMOS l=0.18u w=2u
M489828242 N005 vb2 0 0 NMOS l=0.18u w=2u
M299433472 N001 vb3 N006 0 NMOS l=0.18u w=2u
M623688011 N006 vb2 0 0 NMOS l=0.18u w=2u
VDD VDD 0 1.8
C436541142 vout 0 1p
