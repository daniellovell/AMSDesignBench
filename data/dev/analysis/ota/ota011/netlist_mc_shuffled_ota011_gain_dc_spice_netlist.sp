M714930327 N002 vinn N006 VDD PMOS l=0.18u w=4u
M304040306 N002 vinp N005 VDD PMOS l=0.18u w=4u
M586162412 VDD vb1 N002 VDD PMOS l=0.18u w=4u
M251292964 VDD N001 N003 VDD PMOS l=0.18u w=4u
M368407369 VDD N001 N004 VDD PMOS l=0.18u w=4u
M739512036 N003 vb4 N001 VDD PMOS l=0.18u w=4u
M479266811 N004 vb4 vout VDD PMOS l=0.18u w=4u
M386552534 vout vb3 N005 0 NMOS l=0.18u w=2u
M871111600 N005 vb2 0 0 NMOS l=0.18u w=2u
M529806412 N001 vb3 N006 0 NMOS l=0.18u w=2u
M987475112 N006 vb2 0 0 NMOS l=0.18u w=2u
VDD VDD 0 1.8
C807405600 vout 0 1p
