M852974343 N002 vinn N006 VDD PMOS l=0.18u w=4u
M326061842 N002 vinp N005 VDD PMOS l=0.18u w=4u
M289763653 VDD vb1 N002 VDD PMOS l=0.18u w=4u
M496687798 VDD N001 N003 VDD PMOS l=0.18u w=4u
M657592151 VDD N001 N004 VDD PMOS l=0.18u w=4u
M257879931 N003 vb4 N001 VDD PMOS l=0.18u w=4u
M424363813 N004 vb4 vout VDD PMOS l=0.18u w=4u
M583065341 vout vb3 N005 0 NMOS l=0.18u w=2u
M934075083 N005 vb2 0 0 NMOS l=0.18u w=2u
M463364177 N001 vb3 N006 0 NMOS l=0.18u w=2u
M593853635 N006 vb2 0 0 NMOS l=0.18u w=2u
VDD VDD 0 1.8
C523282858 vout 0 1p
