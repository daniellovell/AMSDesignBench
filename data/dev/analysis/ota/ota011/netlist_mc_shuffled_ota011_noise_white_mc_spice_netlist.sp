M448570634 N002 vinn N006 VDD PMOS l=0.18u w=4u
M695274384 N002 vinp N005 VDD PMOS l=0.18u w=4u
M134242412 VDD vb1 N002 VDD PMOS l=0.18u w=4u
M699379355 VDD N001 N003 VDD PMOS l=0.18u w=4u
M199561696 VDD N001 N004 VDD PMOS l=0.18u w=4u
M531397499 N003 vb4 N001 VDD PMOS l=0.18u w=4u
M382198763 N004 vb4 vout VDD PMOS l=0.18u w=4u
M846044965 vout vb3 N005 0 NMOS l=0.18u w=2u
M944363351 N005 vb2 0 0 NMOS l=0.18u w=2u
M143409358 N001 vb3 N006 0 NMOS l=0.18u w=2u
M140927875 N006 vb2 0 0 NMOS l=0.18u w=2u
VDD VDD 0 1.8
C994319519 vout 0 1p
