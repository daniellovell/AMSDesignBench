M184696492 N002 vinn N006 VDD PMOS l=0.18u w=4u
M415297187 N002 vinp N005 VDD PMOS l=0.18u w=4u
M165994369 VDD vb1 N002 VDD PMOS l=0.18u w=4u
M220996658 VDD N001 N003 VDD PMOS l=0.18u w=4u
M744592549 VDD N001 N004 VDD PMOS l=0.18u w=4u
M430383847 N003 vb4 N001 VDD PMOS l=0.18u w=4u
M357224848 N004 vb4 vout VDD PMOS l=0.18u w=4u
M371622961 vout vb3 N005 0 NMOS l=0.18u w=2u
M692511854 N005 vb2 0 0 NMOS l=0.18u w=2u
M220166449 N001 vb3 N006 0 NMOS l=0.18u w=2u
M204969916 N006 vb2 0 0 NMOS l=0.18u w=2u
VDD VDD 0 1.8
C672453301 vout 0 1p
