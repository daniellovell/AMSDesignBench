M627398688 N002 vinn N006 VDD PMOS l=0.18u w=4u
M79052435 N002 vinp N005 VDD PMOS l=0.18u w=4u
M682143915 VDD vb1 N002 VDD PMOS l=0.18u w=4u
M176214951 VDD N001 N003 VDD PMOS l=0.18u w=4u
M249780581 VDD N001 N004 VDD PMOS l=0.18u w=4u
M760372647 N003 vb4 N001 VDD PMOS l=0.18u w=4u
M952279679 N004 vb4 vout VDD PMOS l=0.18u w=4u
M325438932 vout vb3 N005 0 NMOS l=0.18u w=2u
M652535640 N005 vb2 0 0 NMOS l=0.18u w=2u
M812414169 N001 vb3 N006 0 NMOS l=0.18u w=2u
M497220009 N006 vb2 0 0 NMOS l=0.18u w=2u
VDD VDD 0 1.8
C610337550 vout 0 1p
