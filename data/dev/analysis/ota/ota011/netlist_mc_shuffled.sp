M364393465 N002 vinn N006 VDD PMOS l=0.18u w=4u
M895999739 N002 vinp N005 VDD PMOS l=0.18u w=4u
M350995758 VDD vb1 N002 VDD PMOS l=0.18u w=4u
M951757578 VDD N001 N003 VDD PMOS l=0.18u w=4u
M162284265 VDD N001 N004 VDD PMOS l=0.18u w=4u
M246512114 N003 vb4 N001 VDD PMOS l=0.18u w=4u
M45171201 N004 vb4 vout VDD PMOS l=0.18u w=4u
M856931773 vout vb3 N005 0 NMOS l=0.18u w=2u
M9040491 N005 vb2 0 0 NMOS l=0.18u w=2u
M19994267 N001 vb3 N006 0 NMOS l=0.18u w=2u
M343893028 N006 vb2 0 0 NMOS l=0.18u w=2u
VDD VDD 0 1.8
C913137513 vout 0 1p
