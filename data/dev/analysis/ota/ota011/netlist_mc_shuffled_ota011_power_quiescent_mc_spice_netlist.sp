M69878431 N002 vinn N006 VDD PMOS l=0.18u w=4u
M551362629 N002 vinp N005 VDD PMOS l=0.18u w=4u
M470242255 VDD vb1 N002 VDD PMOS l=0.18u w=4u
M48619535 VDD N001 N003 VDD PMOS l=0.18u w=4u
M775829611 VDD N001 N004 VDD PMOS l=0.18u w=4u
M74645076 N003 vb4 N001 VDD PMOS l=0.18u w=4u
M987201394 N004 vb4 vout VDD PMOS l=0.18u w=4u
M780222035 vout vb3 N005 0 NMOS l=0.18u w=2u
M640867998 N005 vb2 0 0 NMOS l=0.18u w=2u
M174139314 N001 vb3 N006 0 NMOS l=0.18u w=2u
M808267598 N006 vb2 0 0 NMOS l=0.18u w=2u
VDD VDD 0 1.8
C330250724 vout 0 1p
