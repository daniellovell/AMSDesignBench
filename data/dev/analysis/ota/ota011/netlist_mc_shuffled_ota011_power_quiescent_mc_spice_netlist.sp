M567389164 N002 vinn N006 VDD PMOS l=0.18u w=4u
M342594583 N002 vinp N005 VDD PMOS l=0.18u w=4u
M451275934 VDD vb1 N002 VDD PMOS l=0.18u w=4u
M124448753 VDD N001 N003 VDD PMOS l=0.18u w=4u
M353754705 VDD N001 N004 VDD PMOS l=0.18u w=4u
M941432455 N003 vb4 N001 VDD PMOS l=0.18u w=4u
M891223669 N004 vb4 vout VDD PMOS l=0.18u w=4u
M527855250 vout vb3 N005 0 NMOS l=0.18u w=2u
M995346763 N005 vb2 0 0 NMOS l=0.18u w=2u
M437945899 N001 vb3 N006 0 NMOS l=0.18u w=2u
M560829042 N006 vb2 0 0 NMOS l=0.18u w=2u
VDD VDD 0 1.8
C705372037 vout 0 1p
