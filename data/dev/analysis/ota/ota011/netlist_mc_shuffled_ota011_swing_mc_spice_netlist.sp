M698652384 N002 vinn N006 VDD PMOS l=0.18u w=4u
M899584548 N002 vinp N005 VDD PMOS l=0.18u w=4u
M67325317 VDD vb1 N002 VDD PMOS l=0.18u w=4u
M792989956 VDD N001 N003 VDD PMOS l=0.18u w=4u
M766757946 VDD N001 N004 VDD PMOS l=0.18u w=4u
M514917673 N003 vb4 N001 VDD PMOS l=0.18u w=4u
M351239837 N004 vb4 vout VDD PMOS l=0.18u w=4u
M450746939 vout vb3 N005 0 NMOS l=0.18u w=2u
M287390217 N005 vb2 0 0 NMOS l=0.18u w=2u
M214392549 N001 vb3 N006 0 NMOS l=0.18u w=2u
M62381116 N006 vb2 0 0 NMOS l=0.18u w=2u
VDD VDD 0 1.8
C909696327 vout 0 1p
