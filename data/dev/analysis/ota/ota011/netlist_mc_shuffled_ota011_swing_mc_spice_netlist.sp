M427843452 N002 vinn N006 VDD PMOS l=0.18u w=4u
M311327155 N002 vinp N005 VDD PMOS l=0.18u w=4u
M784361240 VDD vb1 N002 VDD PMOS l=0.18u w=4u
M912385072 VDD N001 N003 VDD PMOS l=0.18u w=4u
M798589478 VDD N001 N004 VDD PMOS l=0.18u w=4u
M992280233 N003 vb4 N001 VDD PMOS l=0.18u w=4u
M589938504 N004 vb4 vout VDD PMOS l=0.18u w=4u
M471597263 vout vb3 N005 0 NMOS l=0.18u w=2u
M76757996 N005 vb2 0 0 NMOS l=0.18u w=2u
M58355337 N001 vb3 N006 0 NMOS l=0.18u w=2u
M738320364 N006 vb2 0 0 NMOS l=0.18u w=2u
VDD VDD 0 1.8
C641093942 vout 0 1p
