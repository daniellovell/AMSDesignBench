M819918238 N002 vinn N006 VDD PMOS l=0.18u w=4u
M551920060 N002 vinp N005 VDD PMOS l=0.18u w=4u
M807316507 VDD vb1 N002 VDD PMOS l=0.18u w=4u
M804654863 VDD N001 N003 VDD PMOS l=0.18u w=4u
M513197190 VDD N001 N004 VDD PMOS l=0.18u w=4u
M197783965 N003 vb4 N001 VDD PMOS l=0.18u w=4u
M614560047 N004 vb4 vout VDD PMOS l=0.18u w=4u
M978021577 vout vb3 N005 0 NMOS l=0.18u w=2u
M881342878 N005 vb2 0 0 NMOS l=0.18u w=2u
M998649385 N001 vb3 N006 0 NMOS l=0.18u w=2u
M112126812 N006 vb2 0 0 NMOS l=0.18u w=2u
VDD VDD 0 1.8
C197802034 vout 0 1p
