M26498949 N002 vinn N006 VDD PMOS l=0.18u w=4u
M37966147 N002 vinp N005 VDD PMOS l=0.18u w=4u
M813217574 VDD vb1 N002 VDD PMOS l=0.18u w=4u
M752530693 VDD N001 N003 VDD PMOS l=0.18u w=4u
M913537452 VDD N001 N004 VDD PMOS l=0.18u w=4u
M639357979 N003 vb4 N001 VDD PMOS l=0.18u w=4u
M376625064 N004 vb4 vout VDD PMOS l=0.18u w=4u
M839899451 vout vb3 N005 0 NMOS l=0.18u w=2u
M347259659 N005 vb2 0 0 NMOS l=0.18u w=2u
M231244262 N001 vb3 N006 0 NMOS l=0.18u w=2u
M563836558 N006 vb2 0 0 NMOS l=0.18u w=2u
VDD VDD 0 1.8
C285588265 vout 0 1p
