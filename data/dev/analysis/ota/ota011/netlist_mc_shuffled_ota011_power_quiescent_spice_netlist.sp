M917852313 N002 vinn N006 VDD PMOS l=0.18u w=4u
M551691557 N002 vinp N005 VDD PMOS l=0.18u w=4u
M514221633 VDD vb1 N002 VDD PMOS l=0.18u w=4u
M568580636 VDD N001 N003 VDD PMOS l=0.18u w=4u
M17331149 VDD N001 N004 VDD PMOS l=0.18u w=4u
M164517045 N003 vb4 N001 VDD PMOS l=0.18u w=4u
M476485869 N004 vb4 vout VDD PMOS l=0.18u w=4u
M541819481 vout vb3 N005 0 NMOS l=0.18u w=2u
M724758369 N005 vb2 0 0 NMOS l=0.18u w=2u
M419538188 N001 vb3 N006 0 NMOS l=0.18u w=2u
M850095071 N006 vb2 0 0 NMOS l=0.18u w=2u
VDD VDD 0 1.8
C285310357 vout 0 1p
