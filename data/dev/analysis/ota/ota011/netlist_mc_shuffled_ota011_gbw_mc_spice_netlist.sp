M604267811 N002 vinn N006 VDD PMOS l=0.18u w=4u
M713211396 N002 vinp N005 VDD PMOS l=0.18u w=4u
M953319822 VDD vb1 N002 VDD PMOS l=0.18u w=4u
M532752319 VDD N001 N003 VDD PMOS l=0.18u w=4u
M22812140 VDD N001 N004 VDD PMOS l=0.18u w=4u
M284077345 N003 vb4 N001 VDD PMOS l=0.18u w=4u
M528068405 N004 vb4 vout VDD PMOS l=0.18u w=4u
M118491542 vout vb3 N005 0 NMOS l=0.18u w=2u
M196765119 N005 vb2 0 0 NMOS l=0.18u w=2u
M20592338 N001 vb3 N006 0 NMOS l=0.18u w=2u
M971903727 N006 vb2 0 0 NMOS l=0.18u w=2u
VDD VDD 0 1.8
C867291527 vout 0 1p
