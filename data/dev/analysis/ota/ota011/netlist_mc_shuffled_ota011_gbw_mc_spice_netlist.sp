M217942835 N002 vinn N006 VDD PMOS l=0.18u w=4u
M78576402 N002 vinp N005 VDD PMOS l=0.18u w=4u
M730735638 VDD vb1 N002 VDD PMOS l=0.18u w=4u
M976873470 VDD N001 N003 VDD PMOS l=0.18u w=4u
M954134239 VDD N001 N004 VDD PMOS l=0.18u w=4u
M416216939 N003 vb4 N001 VDD PMOS l=0.18u w=4u
M570069541 N004 vb4 vout VDD PMOS l=0.18u w=4u
M34927634 vout vb3 N005 0 NMOS l=0.18u w=2u
M796899110 N005 vb2 0 0 NMOS l=0.18u w=2u
M280413003 N001 vb3 N006 0 NMOS l=0.18u w=2u
M209746368 N006 vb2 0 0 NMOS l=0.18u w=2u
VDD VDD 0 1.8
C46723855 vout 0 1p
