M858238405 N002 vinn N006 VDD PMOS l=0.18u w=4u
M303315315 N002 vinp N005 VDD PMOS l=0.18u w=4u
M430348032 VDD vb1 N002 VDD PMOS l=0.18u w=4u
M220739185 VDD N001 N003 VDD PMOS l=0.18u w=4u
M942243113 VDD N001 N004 VDD PMOS l=0.18u w=4u
M378505316 N003 vb4 N001 VDD PMOS l=0.18u w=4u
M423163813 N004 vb4 vout VDD PMOS l=0.18u w=4u
M372117599 vout vb3 N005 0 NMOS l=0.18u w=2u
M961052694 N005 vb2 0 0 NMOS l=0.18u w=2u
M878014958 N001 vb3 N006 0 NMOS l=0.18u w=2u
M877998248 N006 vb2 0 0 NMOS l=0.18u w=2u
VDD VDD 0 1.8
C833414276 vout 0 1p
