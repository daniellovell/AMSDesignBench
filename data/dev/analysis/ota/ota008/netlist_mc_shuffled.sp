M989404687 N002 vin 0 0 NMOS l=0.18u w=2u
M904884119 vout vb1 N002 0 NMOS l=0.18u w=2u
M887934412 vout vb2 N001 VDD PMOS l=0.18u w=4u
M459152748 N001 vb3 VDD VDD PMOS l=0.18u w=4u
VDD VDD 0 1.8
C978076835 vout 0 1p
