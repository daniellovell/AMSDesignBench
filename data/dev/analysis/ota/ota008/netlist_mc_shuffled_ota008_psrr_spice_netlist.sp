M626963400 N002 vin 0 0 NMOS l=0.18u w=2u
M913222887 vout vb1 N002 0 NMOS l=0.18u w=2u
M560349948 vout vb2 N001 VDD PMOS l=0.18u w=4u
M550968526 N001 vb3 VDD VDD PMOS l=0.18u w=4u
VDD VDD 0 1.8
C299824596 vout 0 1p
