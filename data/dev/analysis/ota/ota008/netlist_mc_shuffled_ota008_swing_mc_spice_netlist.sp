M542059017 N002 vin 0 0 NMOS l=0.18u w=2u
M226213516 vout vb1 N002 0 NMOS l=0.18u w=2u
M829824191 vout vb2 N001 VDD PMOS l=0.18u w=4u
M740660248 N001 vb3 VDD VDD PMOS l=0.18u w=4u
VDD VDD 0 1.8
C879860773 vout 0 1p
