M973634339 N002 vin 0 0 NMOS l=0.18u w=2u
M901658831 vout vb1 N002 0 NMOS l=0.18u w=2u
M508238685 vout vb2 N001 VDD PMOS l=0.18u w=4u
M978562436 N001 vb3 VDD VDD PMOS l=0.18u w=4u
VDD VDD 0 1.8
C702114452 vout 0 1p
