M282883237 N002 vin 0 0 NMOS l=0.18u w=2u
M731255142 vout vb1 N002 0 NMOS l=0.18u w=2u
M711660051 vout vb2 N001 VDD PMOS l=0.18u w=4u
M10031957 N001 vb3 VDD VDD PMOS l=0.18u w=4u
VDD VDD 0 1.8
C81238640 vout 0 1p
