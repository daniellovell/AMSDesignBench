M553543461 N002 vin 0 0 NMOS l=0.18u w=2u
M113316600 vout vb1 N002 0 NMOS l=0.18u w=2u
M703296152 vout vb2 N001 VDD PMOS l=0.18u w=4u
M524334791 N001 vb3 VDD VDD PMOS l=0.18u w=4u
VDD VDD 0 1.8
C949949360 vout 0 1p
