M256432618 N002 vin 0 0 NMOS l=0.18u w=2u
M824565457 vout vb1 N002 0 NMOS l=0.18u w=2u
M611334874 vout vb2 N001 VDD PMOS l=0.18u w=4u
M140721868 N001 vb3 VDD VDD PMOS l=0.18u w=4u
VDD VDD 0 1.8
C827117264 vout 0 1p
