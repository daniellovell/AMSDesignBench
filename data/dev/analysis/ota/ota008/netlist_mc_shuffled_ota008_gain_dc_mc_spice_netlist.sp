M316157227 N002 vin 0 0 NMOS l=0.18u w=2u
M19823960 vout vb1 N002 0 NMOS l=0.18u w=2u
M27362974 vout vb2 N001 VDD PMOS l=0.18u w=4u
M352798970 N001 vb3 VDD VDD PMOS l=0.18u w=4u
VDD VDD 0 1.8
C275466975 vout 0 1p
