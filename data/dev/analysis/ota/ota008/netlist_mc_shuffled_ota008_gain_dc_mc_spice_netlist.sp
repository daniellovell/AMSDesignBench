M223481086 N002 vin 0 0 NMOS l=0.18u w=2u
M186748968 vout vb1 N002 0 NMOS l=0.18u w=2u
M444583149 vout vb2 N001 VDD PMOS l=0.18u w=4u
M151425655 N001 vb3 VDD VDD PMOS l=0.18u w=4u
VDD VDD 0 1.8
C776518321 vout 0 1p
