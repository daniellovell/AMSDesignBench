M651953278 N002 vin 0 0 NMOS l=0.18u w=2u
M19281145 vout vb1 N002 0 NMOS l=0.18u w=2u
M6532358 vout vb2 N001 VDD PMOS l=0.18u w=4u
M527298404 N001 vb3 VDD VDD PMOS l=0.18u w=4u
VDD VDD 0 1.8
C348209492 vout 0 1p
