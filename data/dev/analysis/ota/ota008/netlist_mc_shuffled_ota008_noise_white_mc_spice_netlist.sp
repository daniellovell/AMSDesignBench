M696999763 N002 vin 0 0 NMOS l=0.18u w=2u
M65873362 vout vb1 N002 0 NMOS l=0.18u w=2u
M747092695 vout vb2 N001 VDD PMOS l=0.18u w=4u
M832166861 N001 vb3 VDD VDD PMOS l=0.18u w=4u
VDD VDD 0 1.8
C214942106 vout 0 1p
