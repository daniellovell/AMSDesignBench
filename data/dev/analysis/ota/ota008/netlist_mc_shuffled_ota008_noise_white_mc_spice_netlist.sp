M987416344 N002 vin 0 0 NMOS l=0.18u w=2u
M179190016 vout vb1 N002 0 NMOS l=0.18u w=2u
M282122940 vout vb2 N001 VDD PMOS l=0.18u w=4u
M731708529 N001 vb3 VDD VDD PMOS l=0.18u w=4u
VDD VDD 0 1.8
C924569574 vout 0 1p
