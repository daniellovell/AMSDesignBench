M251554182 N002 vin 0 0 NMOS l=0.18u w=2u
M382202163 vout vb1 N002 0 NMOS l=0.18u w=2u
M332612602 vout vb2 N001 VDD PMOS l=0.18u w=4u
M961885265 N001 vb3 VDD VDD PMOS l=0.18u w=4u
VDD VDD 0 1.8
C959433926 vout 0 1p
