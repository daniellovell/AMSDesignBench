M389882146 N002 vin 0 0 NMOS l=0.18u w=2u
M341627946 vout vb1 N002 0 NMOS l=0.18u w=2u
M343748032 vout vb2 N001 VDD PMOS l=0.18u w=4u
M217522129 N001 vb3 VDD VDD PMOS l=0.18u w=4u
VDD VDD 0 1.8
C899254266 vout 0 1p
