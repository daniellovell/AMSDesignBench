M456048442 N002 vin 0 0 NMOS l=0.18u w=2u
M350881693 vout vb1 N002 0 NMOS l=0.18u w=2u
M312174460 vout vb2 N001 VDD PMOS l=0.18u w=4u
M128425195 N001 vb3 VDD VDD PMOS l=0.18u w=4u
VDD VDD 0 1.8
C617809321 vout 0 1p
