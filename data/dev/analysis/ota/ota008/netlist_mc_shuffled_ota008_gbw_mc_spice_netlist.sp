M707235846 N002 vin 0 0 NMOS l=0.18u w=2u
M125575525 vout vb1 N002 0 NMOS l=0.18u w=2u
M446364484 vout vb2 N001 VDD PMOS l=0.18u w=4u
M298393741 N001 vb3 VDD VDD PMOS l=0.18u w=4u
VDD VDD 0 1.8
C992838168 vout 0 1p
