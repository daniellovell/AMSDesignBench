M785634859 N002 vin 0 0 NMOS l=0.18u w=2u
M954899265 vout vb1 N002 0 NMOS l=0.18u w=2u
M121558049 vout vb2 N001 VDD PMOS l=0.18u w=4u
M310308882 N001 vb3 VDD VDD PMOS l=0.18u w=4u
VDD VDD 0 1.8
C556751166 vout 0 1p
