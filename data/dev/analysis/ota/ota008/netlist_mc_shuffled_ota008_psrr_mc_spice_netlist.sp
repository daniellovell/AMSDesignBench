M447167090 N002 vin 0 0 NMOS l=0.18u w=2u
M899642165 vout vb1 N002 0 NMOS l=0.18u w=2u
M482386498 vout vb2 N001 VDD PMOS l=0.18u w=4u
M403072355 N001 vb3 VDD VDD PMOS l=0.18u w=4u
VDD VDD 0 1.8
C30692488 vout 0 1p
