M542213324 N002 vin 0 0 NMOS l=0.18u w=2u
M78144057 vout vb1 N002 0 NMOS l=0.18u w=2u
M496919113 vout vb2 N001 VDD PMOS l=0.18u w=4u
M3011545 N001 vb3 VDD VDD PMOS l=0.18u w=4u
VDD VDD 0 1.8
C236233036 vout 0 1p
