M40756391 N002 vin 0 0 NMOS l=0.18u w=2u
M749835452 vout vb1 N002 0 NMOS l=0.18u w=2u
M880384127 vout vb2 N001 VDD PMOS l=0.18u w=4u
M750467334 N001 vb3 VDD VDD PMOS l=0.18u w=4u
VDD VDD 0 1.8
C244357414 vout 0 1p
