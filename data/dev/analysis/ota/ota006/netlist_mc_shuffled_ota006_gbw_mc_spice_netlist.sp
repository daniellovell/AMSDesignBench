C838064687 vop 0 1p
M529712664 N003 vb2 vop VDD PMOS l=0.18u w=4u
M873849523 VDD N001 N003 VDD PMOS l=0.18u w=4u
M779839501 VDD N001 N002 VDD PMOS l=0.18u w=4u
M54030783 N002 vb2 N001 VDD PMOS l=0.18u w=4u
M739754170 N001 vb3 N004 0 NMOS l=0.18u w=2u
M973091789 vop vb3 N005 0 NMOS l=0.18u w=2u
M553449769 N005 vin N006 0 NMOS l=0.18u w=2u
M947872117 N004 vip N006 0 NMOS l=0.18u w=2u
M655988420 N006 vtail 0 0 NMOS l=0.18u w=2u
VDD VDD 0 1.8
