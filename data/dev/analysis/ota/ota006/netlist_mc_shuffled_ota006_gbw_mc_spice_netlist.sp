C651002949 vop 0 1p
M111387740 N003 vb2 vop VDD PMOS l=0.18u w=4u
M232764069 VDD N001 N003 VDD PMOS l=0.18u w=4u
M580144339 VDD N001 N002 VDD PMOS l=0.18u w=4u
M969346472 N002 vb2 N001 VDD PMOS l=0.18u w=4u
M882741945 N001 vb3 N004 0 NMOS l=0.18u w=2u
M324855359 vop vb3 N005 0 NMOS l=0.18u w=2u
M745058082 N005 vin N006 0 NMOS l=0.18u w=2u
M697847375 N004 vip N006 0 NMOS l=0.18u w=2u
M620602688 N006 vtail 0 0 NMOS l=0.18u w=2u
VDD VDD 0 1.8
