C78057898 vop 0 1p
M393063518 N003 vb2 vop VDD PMOS l=0.18u w=4u
M294102431 VDD N001 N003 VDD PMOS l=0.18u w=4u
M774598641 VDD N001 N002 VDD PMOS l=0.18u w=4u
M116388833 N002 vb2 N001 VDD PMOS l=0.18u w=4u
M50580032 N001 vb3 N004 0 NMOS l=0.18u w=2u
M307206842 vop vb3 N005 0 NMOS l=0.18u w=2u
M845493481 N005 vin N006 0 NMOS l=0.18u w=2u
M35703791 N004 vip N006 0 NMOS l=0.18u w=2u
M558158422 N006 vtail 0 0 NMOS l=0.18u w=2u
VDD VDD 0 1.8
