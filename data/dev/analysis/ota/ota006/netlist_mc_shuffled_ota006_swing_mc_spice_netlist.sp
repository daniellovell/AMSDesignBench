C802958738 vop 0 1p
M218225086 N003 vb2 vop VDD PMOS l=0.18u w=4u
M514352979 VDD N001 N003 VDD PMOS l=0.18u w=4u
M989246267 VDD N001 N002 VDD PMOS l=0.18u w=4u
M912911857 N002 vb2 N001 VDD PMOS l=0.18u w=4u
M391915267 N001 vb3 N004 0 NMOS l=0.18u w=2u
M869347973 vop vb3 N005 0 NMOS l=0.18u w=2u
M893679897 N005 vin N006 0 NMOS l=0.18u w=2u
M393148378 N004 vip N006 0 NMOS l=0.18u w=2u
M832662802 N006 vtail 0 0 NMOS l=0.18u w=2u
VDD VDD 0 1.8
