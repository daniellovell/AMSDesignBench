C867057031 vop 0 1p
M238486463 N003 vb2 vop VDD PMOS l=0.18u w=4u
M667577348 VDD N001 N003 VDD PMOS l=0.18u w=4u
M632381592 VDD N001 N002 VDD PMOS l=0.18u w=4u
M550672742 N002 vb2 N001 VDD PMOS l=0.18u w=4u
M121724261 N001 vb3 N004 0 NMOS l=0.18u w=2u
M617443739 vop vb3 N005 0 NMOS l=0.18u w=2u
M667526409 N005 vin N006 0 NMOS l=0.18u w=2u
M520122433 N004 vip N006 0 NMOS l=0.18u w=2u
M301149270 N006 vtail 0 0 NMOS l=0.18u w=2u
VDD VDD 0 1.8
