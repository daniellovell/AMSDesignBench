C792589428 vop 0 1p
M800556620 N003 vb2 vop VDD PMOS l=0.18u w=4u
M456241979 VDD N001 N003 VDD PMOS l=0.18u w=4u
M546224483 VDD N001 N002 VDD PMOS l=0.18u w=4u
M949041421 N002 vb2 N001 VDD PMOS l=0.18u w=4u
M972183280 N001 vb3 N004 0 NMOS l=0.18u w=2u
M994409093 vop vb3 N005 0 NMOS l=0.18u w=2u
M119345010 N005 vin N006 0 NMOS l=0.18u w=2u
M871585126 N004 vip N006 0 NMOS l=0.18u w=2u
M664391723 N006 vtail 0 0 NMOS l=0.18u w=2u
VDD VDD 0 1.8
