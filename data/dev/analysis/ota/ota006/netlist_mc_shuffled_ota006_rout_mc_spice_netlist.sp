C226429910 vop 0 1p
M99431867 N003 vb2 vop VDD PMOS l=0.18u w=4u
M350699934 VDD N001 N003 VDD PMOS l=0.18u w=4u
M95725779 VDD N001 N002 VDD PMOS l=0.18u w=4u
M265072800 N002 vb2 N001 VDD PMOS l=0.18u w=4u
M291442220 N001 vb3 N004 0 NMOS l=0.18u w=2u
M653557530 vop vb3 N005 0 NMOS l=0.18u w=2u
M944673020 N005 vin N006 0 NMOS l=0.18u w=2u
M403659512 N004 vip N006 0 NMOS l=0.18u w=2u
M548684276 N006 vtail 0 0 NMOS l=0.18u w=2u
VDD VDD 0 1.8
