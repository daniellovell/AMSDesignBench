C188582598 vop 0 1p
M304262999 N003 vb2 vop VDD PMOS l=0.18u w=4u
M882476085 VDD N001 N003 VDD PMOS l=0.18u w=4u
M881397670 VDD N001 N002 VDD PMOS l=0.18u w=4u
M664675007 N002 vb2 N001 VDD PMOS l=0.18u w=4u
M736934768 N001 vb3 N004 0 NMOS l=0.18u w=2u
M574841078 vop vb3 N005 0 NMOS l=0.18u w=2u
M947188006 N005 vin N006 0 NMOS l=0.18u w=2u
M695682864 N004 vip N006 0 NMOS l=0.18u w=2u
M917541412 N006 vtail 0 0 NMOS l=0.18u w=2u
VDD VDD 0 1.8
