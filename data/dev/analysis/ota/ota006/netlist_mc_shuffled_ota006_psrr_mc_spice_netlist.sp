C865777454 vop 0 1p
M692173250 N003 vb2 vop VDD PMOS l=0.18u w=4u
M137531388 VDD N001 N003 VDD PMOS l=0.18u w=4u
M3838462 VDD N001 N002 VDD PMOS l=0.18u w=4u
M406252966 N002 vb2 N001 VDD PMOS l=0.18u w=4u
M405943957 N001 vb3 N004 0 NMOS l=0.18u w=2u
M569978716 vop vb3 N005 0 NMOS l=0.18u w=2u
M628757240 N005 vin N006 0 NMOS l=0.18u w=2u
M361056445 N004 vip N006 0 NMOS l=0.18u w=2u
M563385438 N006 vtail 0 0 NMOS l=0.18u w=2u
VDD VDD 0 1.8
