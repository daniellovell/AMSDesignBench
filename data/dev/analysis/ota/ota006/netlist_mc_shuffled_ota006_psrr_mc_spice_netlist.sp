C199216645 vop 0 1p
M249167340 N003 vb2 vop VDD PMOS l=0.18u w=4u
M150470811 VDD N001 N003 VDD PMOS l=0.18u w=4u
M343241231 VDD N001 N002 VDD PMOS l=0.18u w=4u
M784760628 N002 vb2 N001 VDD PMOS l=0.18u w=4u
M822578241 N001 vb3 N004 0 NMOS l=0.18u w=2u
M340378831 vop vb3 N005 0 NMOS l=0.18u w=2u
M64478322 N005 vin N006 0 NMOS l=0.18u w=2u
M486128736 N004 vip N006 0 NMOS l=0.18u w=2u
M368027869 N006 vtail 0 0 NMOS l=0.18u w=2u
VDD VDD 0 1.8
