C99881742 vop 0 1p
M211139171 N003 vb2 vop VDD PMOS l=0.18u w=4u
M78453050 VDD N001 N003 VDD PMOS l=0.18u w=4u
M735180695 VDD N001 N002 VDD PMOS l=0.18u w=4u
M631029316 N002 vb2 N001 VDD PMOS l=0.18u w=4u
M57006048 N001 vb3 N004 0 NMOS l=0.18u w=2u
M836910060 vop vb3 N005 0 NMOS l=0.18u w=2u
M313702561 N005 vin N006 0 NMOS l=0.18u w=2u
M479425625 N004 vip N006 0 NMOS l=0.18u w=2u
M8081808 N006 vtail 0 0 NMOS l=0.18u w=2u
VDD VDD 0 1.8
