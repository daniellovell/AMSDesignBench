C706420231 vop 0 1p
M123460172 N003 vb2 vop VDD PMOS l=0.18u w=4u
M540762646 VDD N001 N003 VDD PMOS l=0.18u w=4u
M610399914 VDD N001 N002 VDD PMOS l=0.18u w=4u
M847674258 N002 vb2 N001 VDD PMOS l=0.18u w=4u
M918196769 N001 vb3 N004 0 NMOS l=0.18u w=2u
M169521250 vop vb3 N005 0 NMOS l=0.18u w=2u
M68967104 N005 vin N006 0 NMOS l=0.18u w=2u
M719620891 N004 vip N006 0 NMOS l=0.18u w=2u
M376389159 N006 vtail 0 0 NMOS l=0.18u w=2u
VDD VDD 0 1.8
