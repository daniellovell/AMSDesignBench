C992722246 vop 0 1p
M435116938 N003 vb2 vop VDD PMOS l=0.18u w=4u
M936334933 VDD N001 N003 VDD PMOS l=0.18u w=4u
M216741199 VDD N001 N002 VDD PMOS l=0.18u w=4u
M10451074 N002 vb2 N001 VDD PMOS l=0.18u w=4u
M884898037 N001 vb3 N004 0 NMOS l=0.18u w=2u
M165880452 vop vb3 N005 0 NMOS l=0.18u w=2u
M909142487 N005 vin N006 0 NMOS l=0.18u w=2u
M911287738 N004 vip N006 0 NMOS l=0.18u w=2u
M480461699 N006 vtail 0 0 NMOS l=0.18u w=2u
VDD VDD 0 1.8
