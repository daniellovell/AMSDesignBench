C426693753 vop 0 1p
M409819944 N003 vb2 vop VDD PMOS l=0.18u w=4u
M421988879 VDD N001 N003 VDD PMOS l=0.18u w=4u
M416754125 VDD N001 N002 VDD PMOS l=0.18u w=4u
M324480002 N002 vb2 N001 VDD PMOS l=0.18u w=4u
M232222376 N001 vb3 N004 0 NMOS l=0.18u w=2u
M809164659 vop vb3 N005 0 NMOS l=0.18u w=2u
M149540803 N005 vin N006 0 NMOS l=0.18u w=2u
M501316303 N004 vip N006 0 NMOS l=0.18u w=2u
M944664789 N006 vtail 0 0 NMOS l=0.18u w=2u
VDD VDD 0 1.8
