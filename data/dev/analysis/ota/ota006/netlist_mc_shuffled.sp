C90136537 vop 0 1p
M550529279 N003 vb2 vop VDD PMOS l=0.18u w=4u
M838290278 VDD N001 N003 VDD PMOS l=0.18u w=4u
M345538696 VDD N001 N002 VDD PMOS l=0.18u w=4u
M503083434 N002 vb2 N001 VDD PMOS l=0.18u w=4u
M29346235 N001 vb3 N004 0 NMOS l=0.18u w=2u
M247584965 vop vb3 N005 0 NMOS l=0.18u w=2u
M861156296 N005 vin N006 0 NMOS l=0.18u w=2u
M266976426 N004 vip N006 0 NMOS l=0.18u w=2u
M919268135 N006 vtail 0 0 NMOS l=0.18u w=2u
VDD VDD 0 1.8
