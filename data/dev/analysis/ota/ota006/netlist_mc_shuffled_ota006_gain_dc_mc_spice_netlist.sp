C897991095 vop 0 1p
M101711463 N003 vb2 vop VDD PMOS l=0.18u w=4u
M867861031 VDD N001 N003 VDD PMOS l=0.18u w=4u
M143896803 VDD N001 N002 VDD PMOS l=0.18u w=4u
M272218204 N002 vb2 N001 VDD PMOS l=0.18u w=4u
M604274312 N001 vb3 N004 0 NMOS l=0.18u w=2u
M774352948 vop vb3 N005 0 NMOS l=0.18u w=2u
M284989270 N005 vin N006 0 NMOS l=0.18u w=2u
M281441433 N004 vip N006 0 NMOS l=0.18u w=2u
M624541583 N006 vtail 0 0 NMOS l=0.18u w=2u
VDD VDD 0 1.8
