C982974304 vop 0 1p
M372609980 N003 vb2 vop VDD PMOS l=0.18u w=4u
M199071382 VDD N001 N003 VDD PMOS l=0.18u w=4u
M544856170 VDD N001 N002 VDD PMOS l=0.18u w=4u
M733737023 N002 vb2 N001 VDD PMOS l=0.18u w=4u
M86419534 N001 vb3 N004 0 NMOS l=0.18u w=2u
M730334380 vop vb3 N005 0 NMOS l=0.18u w=2u
M463043807 N005 vin N006 0 NMOS l=0.18u w=2u
M129957200 N004 vip N006 0 NMOS l=0.18u w=2u
M238731683 N006 vtail 0 0 NMOS l=0.18u w=2u
VDD VDD 0 1.8
