C752010267 vop 0 1p
M709623891 N003 vb2 vop VDD PMOS l=0.18u w=4u
M439605224 VDD N001 N003 VDD PMOS l=0.18u w=4u
M190991625 VDD N001 N002 VDD PMOS l=0.18u w=4u
M227839064 N002 vb2 N001 VDD PMOS l=0.18u w=4u
M251116408 N001 vb3 N004 0 NMOS l=0.18u w=2u
M662897703 vop vb3 N005 0 NMOS l=0.18u w=2u
M13666348 N005 vin N006 0 NMOS l=0.18u w=2u
M911486422 N004 vip N006 0 NMOS l=0.18u w=2u
M318250681 N006 vtail 0 0 NMOS l=0.18u w=2u
VDD VDD 0 1.8
