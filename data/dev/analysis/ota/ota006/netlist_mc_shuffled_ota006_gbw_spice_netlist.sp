C43027071 vop 0 1p
M55631155 N003 vb2 vop VDD PMOS l=0.18u w=4u
M324529929 VDD N001 N003 VDD PMOS l=0.18u w=4u
M634195251 VDD N001 N002 VDD PMOS l=0.18u w=4u
M143773644 N002 vb2 N001 VDD PMOS l=0.18u w=4u
M697632609 N001 vb3 N004 0 NMOS l=0.18u w=2u
M349371659 vop vb3 N005 0 NMOS l=0.18u w=2u
M667473113 N005 vin N006 0 NMOS l=0.18u w=2u
M665634234 N004 vip N006 0 NMOS l=0.18u w=2u
M561763746 N006 vtail 0 0 NMOS l=0.18u w=2u
VDD VDD 0 1.8
