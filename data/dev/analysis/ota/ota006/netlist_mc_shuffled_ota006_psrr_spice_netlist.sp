C435776174 vop 0 1p
M438791157 N003 vb2 vop VDD PMOS l=0.18u w=4u
M972469435 VDD N001 N003 VDD PMOS l=0.18u w=4u
M397550767 VDD N001 N002 VDD PMOS l=0.18u w=4u
M887931199 N002 vb2 N001 VDD PMOS l=0.18u w=4u
M978436071 N001 vb3 N004 0 NMOS l=0.18u w=2u
M807321039 vop vb3 N005 0 NMOS l=0.18u w=2u
M952984277 N005 vin N006 0 NMOS l=0.18u w=2u
M148899223 N004 vip N006 0 NMOS l=0.18u w=2u
M8662302 N006 vtail 0 0 NMOS l=0.18u w=2u
VDD VDD 0 1.8
