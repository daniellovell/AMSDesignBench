C302244623 vop 0 1p
M722362744 N003 vb2 vop VDD PMOS l=0.18u w=4u
M548485716 VDD N001 N003 VDD PMOS l=0.18u w=4u
M83274234 VDD N001 N002 VDD PMOS l=0.18u w=4u
M547497846 N002 vb2 N001 VDD PMOS l=0.18u w=4u
M93893561 N001 vb3 N004 0 NMOS l=0.18u w=2u
M647805215 vop vb3 N005 0 NMOS l=0.18u w=2u
M489535638 N005 vin N006 0 NMOS l=0.18u w=2u
M542534760 N004 vip N006 0 NMOS l=0.18u w=2u
M238523857 N006 vtail 0 0 NMOS l=0.18u w=2u
VDD VDD 0 1.8
