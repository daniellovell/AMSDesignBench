M744168947 N001 vinn N005 VDD PMOS l=0.18u w=4u
M333797223 N001 vinp N004 VDD PMOS l=0.18u w=4u
M990786810 VDD vb1 N001 VDD PMOS l=0.18u w=4u
M841479869 VDD vb5 N002 VDD PMOS l=0.18u w=4u
M372485222 VDD vb5 N003 VDD PMOS l=0.18u w=4u
M379222514 N002 vb4 voutp VDD PMOS l=0.18u w=4u
M633145659 N003 vb4 voutn VDD PMOS l=0.18u w=4u
M909378035 voutn vb3 N004 0 NMOS l=0.18u w=2u
M179743376 N004 vb2 0 0 NMOS l=0.18u w=2u
M831236074 voutp vb3 N005 0 NMOS l=0.18u w=2u
M459685770 N005 vb2 0 0 NMOS l=0.18u w=2u
VDD VDD 0 1.8
C284223013 voutn 0 1p
C152215721 voutp 0 1p
