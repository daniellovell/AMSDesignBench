M346332749 N001 vinn N005 VDD PMOS l=0.18u w=4u
M386709090 N001 vinp N004 VDD PMOS l=0.18u w=4u
M952098254 VDD vb1 N001 VDD PMOS l=0.18u w=4u
M596564619 VDD vb5 N002 VDD PMOS l=0.18u w=4u
M12098289 VDD vb5 N003 VDD PMOS l=0.18u w=4u
M830659311 N002 vb4 voutp VDD PMOS l=0.18u w=4u
M686689371 N003 vb4 voutn VDD PMOS l=0.18u w=4u
M916508826 voutn vb3 N004 0 NMOS l=0.18u w=2u
M878570810 N004 vb2 0 0 NMOS l=0.18u w=2u
M568783739 voutp vb3 N005 0 NMOS l=0.18u w=2u
M720236283 N005 vb2 0 0 NMOS l=0.18u w=2u
VDD VDD 0 1.8
C453123268 voutn 0 1p
C653679289 voutp 0 1p
