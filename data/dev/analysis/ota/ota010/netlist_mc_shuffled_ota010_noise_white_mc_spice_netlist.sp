M424526181 N001 vinn N005 VDD PMOS l=0.18u w=4u
M522728933 N001 vinp N004 VDD PMOS l=0.18u w=4u
M429679675 VDD vb1 N001 VDD PMOS l=0.18u w=4u
M987373137 VDD vb5 N002 VDD PMOS l=0.18u w=4u
M826865608 VDD vb5 N003 VDD PMOS l=0.18u w=4u
M842203350 N002 vb4 voutp VDD PMOS l=0.18u w=4u
M845631647 N003 vb4 voutn VDD PMOS l=0.18u w=4u
M11185184 voutn vb3 N004 0 NMOS l=0.18u w=2u
M210838725 N004 vb2 0 0 NMOS l=0.18u w=2u
M524354908 voutp vb3 N005 0 NMOS l=0.18u w=2u
M404037480 N005 vb2 0 0 NMOS l=0.18u w=2u
VDD VDD 0 1.8
C627917019 voutn 0 1p
C310791748 voutp 0 1p
