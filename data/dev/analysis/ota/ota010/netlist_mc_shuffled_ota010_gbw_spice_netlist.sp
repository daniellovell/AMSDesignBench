M608028160 N001 vinn N005 VDD PMOS l=0.18u w=4u
M899934155 N001 vinp N004 VDD PMOS l=0.18u w=4u
M261642680 VDD vb1 N001 VDD PMOS l=0.18u w=4u
M698778016 VDD vb5 N002 VDD PMOS l=0.18u w=4u
M34026725 VDD vb5 N003 VDD PMOS l=0.18u w=4u
M841828906 N002 vb4 voutp VDD PMOS l=0.18u w=4u
M176356438 N003 vb4 voutn VDD PMOS l=0.18u w=4u
M294207193 voutn vb3 N004 0 NMOS l=0.18u w=2u
M100047166 N004 vb2 0 0 NMOS l=0.18u w=2u
M417526266 voutp vb3 N005 0 NMOS l=0.18u w=2u
M429677758 N005 vb2 0 0 NMOS l=0.18u w=2u
VDD VDD 0 1.8
C484234959 voutn 0 1p
C336970392 voutp 0 1p
