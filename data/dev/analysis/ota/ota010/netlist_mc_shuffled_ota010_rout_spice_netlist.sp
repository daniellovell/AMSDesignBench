M586028531 N001 vinn N005 VDD PMOS l=0.18u w=4u
M523626010 N001 vinp N004 VDD PMOS l=0.18u w=4u
M328038328 VDD vb1 N001 VDD PMOS l=0.18u w=4u
M287517126 VDD vb5 N002 VDD PMOS l=0.18u w=4u
M38282797 VDD vb5 N003 VDD PMOS l=0.18u w=4u
M510496130 N002 vb4 voutp VDD PMOS l=0.18u w=4u
M195090797 N003 vb4 voutn VDD PMOS l=0.18u w=4u
M92986514 voutn vb3 N004 0 NMOS l=0.18u w=2u
M175202515 N004 vb2 0 0 NMOS l=0.18u w=2u
M283753700 voutp vb3 N005 0 NMOS l=0.18u w=2u
M31650822 N005 vb2 0 0 NMOS l=0.18u w=2u
VDD VDD 0 1.8
C769879265 voutn 0 1p
C618725392 voutp 0 1p
