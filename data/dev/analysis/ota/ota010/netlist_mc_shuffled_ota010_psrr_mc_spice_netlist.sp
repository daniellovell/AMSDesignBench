M745915758 N001 vinn N005 VDD PMOS l=0.18u w=4u
M141378294 N001 vinp N004 VDD PMOS l=0.18u w=4u
M673564895 VDD vb1 N001 VDD PMOS l=0.18u w=4u
M562286255 VDD vb5 N002 VDD PMOS l=0.18u w=4u
M476745262 VDD vb5 N003 VDD PMOS l=0.18u w=4u
M911797221 N002 vb4 voutp VDD PMOS l=0.18u w=4u
M338571779 N003 vb4 voutn VDD PMOS l=0.18u w=4u
M133288320 voutn vb3 N004 0 NMOS l=0.18u w=2u
M841181833 N004 vb2 0 0 NMOS l=0.18u w=2u
M240949141 voutp vb3 N005 0 NMOS l=0.18u w=2u
M870540344 N005 vb2 0 0 NMOS l=0.18u w=2u
VDD VDD 0 1.8
C833315083 voutn 0 1p
C174669488 voutp 0 1p
