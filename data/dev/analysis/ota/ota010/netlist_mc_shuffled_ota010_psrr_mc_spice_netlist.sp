M206497235 N001 vinn N005 VDD PMOS l=0.18u w=4u
M748283659 N001 vinp N004 VDD PMOS l=0.18u w=4u
M484699266 VDD vb1 N001 VDD PMOS l=0.18u w=4u
M324443927 VDD vb5 N002 VDD PMOS l=0.18u w=4u
M751508645 VDD vb5 N003 VDD PMOS l=0.18u w=4u
M551622033 N002 vb4 voutp VDD PMOS l=0.18u w=4u
M968678401 N003 vb4 voutn VDD PMOS l=0.18u w=4u
M918741365 voutn vb3 N004 0 NMOS l=0.18u w=2u
M640403591 N004 vb2 0 0 NMOS l=0.18u w=2u
M321951229 voutp vb3 N005 0 NMOS l=0.18u w=2u
M826851947 N005 vb2 0 0 NMOS l=0.18u w=2u
VDD VDD 0 1.8
C270754421 voutn 0 1p
C331064703 voutp 0 1p
