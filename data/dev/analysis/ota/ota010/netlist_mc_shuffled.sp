M378609003 N001 vinn N005 VDD PMOS l=0.18u w=4u
M270377084 N001 vinp N004 VDD PMOS l=0.18u w=4u
M368435163 VDD vb1 N001 VDD PMOS l=0.18u w=4u
M448580317 VDD vb5 N002 VDD PMOS l=0.18u w=4u
M967360010 VDD vb5 N003 VDD PMOS l=0.18u w=4u
M612184072 N002 vb4 voutp VDD PMOS l=0.18u w=4u
M750801376 N003 vb4 voutn VDD PMOS l=0.18u w=4u
M883703472 voutn vb3 N004 0 NMOS l=0.18u w=2u
M706485603 N004 vb2 0 0 NMOS l=0.18u w=2u
M177114287 voutp vb3 N005 0 NMOS l=0.18u w=2u
M334944704 N005 vb2 0 0 NMOS l=0.18u w=2u
VDD VDD 0 1.8
C11219673 voutn 0 1p
C657780753 voutp 0 1p
