M826399427 N001 vinn N005 VDD PMOS l=0.18u w=4u
M836112746 N001 vinp N004 VDD PMOS l=0.18u w=4u
M314902388 VDD vb1 N001 VDD PMOS l=0.18u w=4u
M391716363 VDD vb5 N002 VDD PMOS l=0.18u w=4u
M117253281 VDD vb5 N003 VDD PMOS l=0.18u w=4u
M217887456 N002 vb4 voutp VDD PMOS l=0.18u w=4u
M917750263 N003 vb4 voutn VDD PMOS l=0.18u w=4u
M608526331 voutn vb3 N004 0 NMOS l=0.18u w=2u
M388396536 N004 vb2 0 0 NMOS l=0.18u w=2u
M729824634 voutp vb3 N005 0 NMOS l=0.18u w=2u
M402224133 N005 vb2 0 0 NMOS l=0.18u w=2u
VDD VDD 0 1.8
C504062358 voutn 0 1p
C855008045 voutp 0 1p
