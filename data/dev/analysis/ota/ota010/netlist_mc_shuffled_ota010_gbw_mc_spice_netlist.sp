M797759442 N001 vinn N005 VDD PMOS l=0.18u w=4u
M912772579 N001 vinp N004 VDD PMOS l=0.18u w=4u
M670953379 VDD vb1 N001 VDD PMOS l=0.18u w=4u
M71053129 VDD vb5 N002 VDD PMOS l=0.18u w=4u
M456479337 VDD vb5 N003 VDD PMOS l=0.18u w=4u
M615787008 N002 vb4 voutp VDD PMOS l=0.18u w=4u
M87996153 N003 vb4 voutn VDD PMOS l=0.18u w=4u
M225004929 voutn vb3 N004 0 NMOS l=0.18u w=2u
M884332240 N004 vb2 0 0 NMOS l=0.18u w=2u
M687555431 voutp vb3 N005 0 NMOS l=0.18u w=2u
M276458847 N005 vb2 0 0 NMOS l=0.18u w=2u
VDD VDD 0 1.8
C491836686 voutn 0 1p
C781180570 voutp 0 1p
