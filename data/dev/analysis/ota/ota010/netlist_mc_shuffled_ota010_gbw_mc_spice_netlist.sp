M196035446 N001 vinn N005 VDD PMOS l=0.18u w=4u
M681713676 N001 vinp N004 VDD PMOS l=0.18u w=4u
M896307569 VDD vb1 N001 VDD PMOS l=0.18u w=4u
M842222903 VDD vb5 N002 VDD PMOS l=0.18u w=4u
M836102697 VDD vb5 N003 VDD PMOS l=0.18u w=4u
M985196793 N002 vb4 voutp VDD PMOS l=0.18u w=4u
M960474202 N003 vb4 voutn VDD PMOS l=0.18u w=4u
M433584099 voutn vb3 N004 0 NMOS l=0.18u w=2u
M999996913 N004 vb2 0 0 NMOS l=0.18u w=2u
M475073928 voutp vb3 N005 0 NMOS l=0.18u w=2u
M987573348 N005 vb2 0 0 NMOS l=0.18u w=2u
VDD VDD 0 1.8
C967513729 voutn 0 1p
C97697948 voutp 0 1p
