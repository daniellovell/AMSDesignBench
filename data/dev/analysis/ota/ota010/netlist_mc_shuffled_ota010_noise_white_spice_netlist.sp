M999412647 N001 vinn N005 VDD PMOS l=0.18u w=4u
M162777402 N001 vinp N004 VDD PMOS l=0.18u w=4u
M479000026 VDD vb1 N001 VDD PMOS l=0.18u w=4u
M960116842 VDD vb5 N002 VDD PMOS l=0.18u w=4u
M755972095 VDD vb5 N003 VDD PMOS l=0.18u w=4u
M217531350 N002 vb4 voutp VDD PMOS l=0.18u w=4u
M67979949 N003 vb4 voutn VDD PMOS l=0.18u w=4u
M275485901 voutn vb3 N004 0 NMOS l=0.18u w=2u
M35158486 N004 vb2 0 0 NMOS l=0.18u w=2u
M188385961 voutp vb3 N005 0 NMOS l=0.18u w=2u
M790975821 N005 vb2 0 0 NMOS l=0.18u w=2u
VDD VDD 0 1.8
C119799339 voutn 0 1p
C271865139 voutp 0 1p
