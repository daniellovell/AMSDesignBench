M517474227 N001 vinn N005 VDD PMOS l=0.18u w=4u
M231534843 N001 vinp N004 VDD PMOS l=0.18u w=4u
M375743293 VDD vb1 N001 VDD PMOS l=0.18u w=4u
M338429875 VDD vb5 N002 VDD PMOS l=0.18u w=4u
M707571857 VDD vb5 N003 VDD PMOS l=0.18u w=4u
M473499061 N002 vb4 voutp VDD PMOS l=0.18u w=4u
M181738980 N003 vb4 voutn VDD PMOS l=0.18u w=4u
M869732551 voutn vb3 N004 0 NMOS l=0.18u w=2u
M751803026 N004 vb2 0 0 NMOS l=0.18u w=2u
M656376535 voutp vb3 N005 0 NMOS l=0.18u w=2u
M937724117 N005 vb2 0 0 NMOS l=0.18u w=2u
VDD VDD 0 1.8
C518086445 voutn 0 1p
C974082829 voutp 0 1p
