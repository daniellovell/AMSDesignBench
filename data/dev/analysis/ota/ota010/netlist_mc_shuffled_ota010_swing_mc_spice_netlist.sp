M238637796 N001 vinn N005 VDD PMOS l=0.18u w=4u
M607451053 N001 vinp N004 VDD PMOS l=0.18u w=4u
M848173931 VDD vb1 N001 VDD PMOS l=0.18u w=4u
M306254956 VDD vb5 N002 VDD PMOS l=0.18u w=4u
M552154262 VDD vb5 N003 VDD PMOS l=0.18u w=4u
M935672898 N002 vb4 voutp VDD PMOS l=0.18u w=4u
M119079135 N003 vb4 voutn VDD PMOS l=0.18u w=4u
M955376509 voutn vb3 N004 0 NMOS l=0.18u w=2u
M835575 N004 vb2 0 0 NMOS l=0.18u w=2u
M463131981 voutp vb3 N005 0 NMOS l=0.18u w=2u
M982889675 N005 vb2 0 0 NMOS l=0.18u w=2u
VDD VDD 0 1.8
C797032651 voutn 0 1p
C174238849 voutp 0 1p
