M588110905 N001 vinn N005 VDD PMOS l=0.18u w=4u
M581067645 N001 vinp N004 VDD PMOS l=0.18u w=4u
M760486282 VDD vb1 N001 VDD PMOS l=0.18u w=4u
M960593853 VDD vb5 N002 VDD PMOS l=0.18u w=4u
M328875537 VDD vb5 N003 VDD PMOS l=0.18u w=4u
M539644457 N002 vb4 voutp VDD PMOS l=0.18u w=4u
M611713706 N003 vb4 voutn VDD PMOS l=0.18u w=4u
M721991593 voutn vb3 N004 0 NMOS l=0.18u w=2u
M327797081 N004 vb2 0 0 NMOS l=0.18u w=2u
M597320645 voutp vb3 N005 0 NMOS l=0.18u w=2u
M626812659 N005 vb2 0 0 NMOS l=0.18u w=2u
VDD VDD 0 1.8
C566932060 voutn 0 1p
C83294241 voutp 0 1p
