M555458135 N001 vinn N005 VDD PMOS l=0.18u w=4u
M697866546 N001 vinp N004 VDD PMOS l=0.18u w=4u
M298380367 VDD vb1 N001 VDD PMOS l=0.18u w=4u
M621227184 VDD vb5 N002 VDD PMOS l=0.18u w=4u
M808601802 VDD vb5 N003 VDD PMOS l=0.18u w=4u
M365328867 N002 vb4 voutp VDD PMOS l=0.18u w=4u
M485408023 N003 vb4 voutn VDD PMOS l=0.18u w=4u
M52670826 voutn vb3 N004 0 NMOS l=0.18u w=2u
M194256094 N004 vb2 0 0 NMOS l=0.18u w=2u
M299126102 voutp vb3 N005 0 NMOS l=0.18u w=2u
M889939016 N005 vb2 0 0 NMOS l=0.18u w=2u
VDD VDD 0 1.8
C410918284 voutn 0 1p
C682527058 voutp 0 1p
