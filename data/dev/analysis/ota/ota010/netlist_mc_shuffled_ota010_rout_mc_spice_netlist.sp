M34879396 N001 vinn N005 VDD PMOS l=0.18u w=4u
M567073856 N001 vinp N004 VDD PMOS l=0.18u w=4u
M989938342 VDD vb1 N001 VDD PMOS l=0.18u w=4u
M449694305 VDD vb5 N002 VDD PMOS l=0.18u w=4u
M896402084 VDD vb5 N003 VDD PMOS l=0.18u w=4u
M306051288 N002 vb4 voutp VDD PMOS l=0.18u w=4u
M436635887 N003 vb4 voutn VDD PMOS l=0.18u w=4u
M542971043 voutn vb3 N004 0 NMOS l=0.18u w=2u
M431821002 N004 vb2 0 0 NMOS l=0.18u w=2u
M8079588 voutp vb3 N005 0 NMOS l=0.18u w=2u
M986718177 N005 vb2 0 0 NMOS l=0.18u w=2u
VDD VDD 0 1.8
C366104710 voutn 0 1p
C878012549 voutp 0 1p
