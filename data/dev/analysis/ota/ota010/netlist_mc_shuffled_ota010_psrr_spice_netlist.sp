M94292059 N001 vinn N005 VDD PMOS l=0.18u w=4u
M176320268 N001 vinp N004 VDD PMOS l=0.18u w=4u
M946736930 VDD vb1 N001 VDD PMOS l=0.18u w=4u
M570542187 VDD vb5 N002 VDD PMOS l=0.18u w=4u
M513212619 VDD vb5 N003 VDD PMOS l=0.18u w=4u
M418277901 N002 vb4 voutp VDD PMOS l=0.18u w=4u
M934323202 N003 vb4 voutn VDD PMOS l=0.18u w=4u
M945208870 voutn vb3 N004 0 NMOS l=0.18u w=2u
M366449906 N004 vb2 0 0 NMOS l=0.18u w=2u
M571992780 voutp vb3 N005 0 NMOS l=0.18u w=2u
M233720198 N005 vb2 0 0 NMOS l=0.18u w=2u
VDD VDD 0 1.8
C72722138 voutn 0 1p
C362103366 voutp 0 1p
