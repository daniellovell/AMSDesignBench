M148135679 N001 vinn N005 VDD PMOS l=0.18u w=4u
M391450062 N001 vinp N004 VDD PMOS l=0.18u w=4u
M703424188 VDD vb1 N001 VDD PMOS l=0.18u w=4u
M668711022 VDD vb5 N002 VDD PMOS l=0.18u w=4u
M426109537 VDD vb5 N003 VDD PMOS l=0.18u w=4u
M443201818 N002 vb4 voutp VDD PMOS l=0.18u w=4u
M715201956 N003 vb4 voutn VDD PMOS l=0.18u w=4u
M561501965 voutn vb3 N004 0 NMOS l=0.18u w=2u
M916482222 N004 vb2 0 0 NMOS l=0.18u w=2u
M722355646 voutp vb3 N005 0 NMOS l=0.18u w=2u
M128435980 N005 vb2 0 0 NMOS l=0.18u w=2u
VDD VDD 0 1.8
C211851876 voutn 0 1p
C688663533 voutp 0 1p
