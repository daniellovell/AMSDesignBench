M628840144 N001 vinn N005 VDD PMOS l=0.18u w=4u
M797947637 N001 vinp N004 VDD PMOS l=0.18u w=4u
M935241428 VDD vb1 N001 VDD PMOS l=0.18u w=4u
M937221756 VDD vb5 N002 VDD PMOS l=0.18u w=4u
M274616162 VDD vb5 N003 VDD PMOS l=0.18u w=4u
M515484886 N002 vb4 voutp VDD PMOS l=0.18u w=4u
M582374378 N003 vb4 voutn VDD PMOS l=0.18u w=4u
M483654048 voutn vb3 N004 0 NMOS l=0.18u w=2u
M485464251 N004 vb2 0 0 NMOS l=0.18u w=2u
M57764342 voutp vb3 N005 0 NMOS l=0.18u w=2u
M697377271 N005 vb2 0 0 NMOS l=0.18u w=2u
VDD VDD 0 1.8
C773701538 voutn 0 1p
C641411146 voutp 0 1p
