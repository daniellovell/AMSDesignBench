M488181076 N001 vinn N005 VDD PMOS l=0.18u w=4u
M257297466 N001 vinp N004 VDD PMOS l=0.18u w=4u
M250929558 VDD vb1 N001 VDD PMOS l=0.18u w=4u
M787633443 VDD vb5 N002 VDD PMOS l=0.18u w=4u
M95862819 VDD vb5 N003 VDD PMOS l=0.18u w=4u
M102193286 N002 vb4 voutp VDD PMOS l=0.18u w=4u
M310713216 N003 vb4 voutn VDD PMOS l=0.18u w=4u
M100726998 voutn vb3 N004 0 NMOS l=0.18u w=2u
M623364791 N004 vb2 0 0 NMOS l=0.18u w=2u
M907610110 voutp vb3 N005 0 NMOS l=0.18u w=2u
M565520649 N005 vb2 0 0 NMOS l=0.18u w=2u
VDD VDD 0 1.8
C929464623 voutn 0 1p
C877692669 voutp 0 1p
