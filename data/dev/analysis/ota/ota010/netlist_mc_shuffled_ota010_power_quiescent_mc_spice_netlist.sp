M70177066 N001 vinn N005 VDD PMOS l=0.18u w=4u
M296607520 N001 vinp N004 VDD PMOS l=0.18u w=4u
M360201334 VDD vb1 N001 VDD PMOS l=0.18u w=4u
M750198420 VDD vb5 N002 VDD PMOS l=0.18u w=4u
M294777183 VDD vb5 N003 VDD PMOS l=0.18u w=4u
M619687588 N002 vb4 voutp VDD PMOS l=0.18u w=4u
M325771291 N003 vb4 voutn VDD PMOS l=0.18u w=4u
M444134331 voutn vb3 N004 0 NMOS l=0.18u w=2u
M762915241 N004 vb2 0 0 NMOS l=0.18u w=2u
M702062678 voutp vb3 N005 0 NMOS l=0.18u w=2u
M358115086 N005 vb2 0 0 NMOS l=0.18u w=2u
VDD VDD 0 1.8
C723715695 voutn 0 1p
C878312372 voutp 0 1p
