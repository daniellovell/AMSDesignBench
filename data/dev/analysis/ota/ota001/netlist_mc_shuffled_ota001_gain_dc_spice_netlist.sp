M304278441 n1 vinp ntail 0 nch W=2u L=0.18u
M215337687 vout vinn ntail 0 nch W=2u L=0.18u
M546242632 ntail vbias_n 0 0 nch W=1u L=0.5u
M768744510 vout n1 VDD VDD pch W=4u L=0.18u
M141240590 n1 n1 VDD VDD pch W=4u L=0.18u
VDD VDD 0 1.8
C859093405 vout 0 1p
