M633256775 n1 vinp ntail 0 nch W=2u L=0.18u
M24890763 vout vinn ntail 0 nch W=2u L=0.18u
M595881794 ntail vbias_n 0 0 nch W=1u L=0.5u
M667681935 vout n1 VDD VDD pch W=4u L=0.18u
M756488867 n1 n1 VDD VDD pch W=4u L=0.18u
VDD VDD 0 1.8
C143707705 vout 0 1p
