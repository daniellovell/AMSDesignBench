M636780748 n1 vinp ntail 0 nch W=2u L=0.18u
M380014010 vout vinn ntail 0 nch W=2u L=0.18u
M192405399 ntail vbias_n 0 0 nch W=1u L=0.5u
M749063345 vout n1 VDD VDD pch W=4u L=0.18u
M791966245 n1 n1 VDD VDD pch W=4u L=0.18u
VDD VDD 0 1.8
C121251401 vout 0 1p
