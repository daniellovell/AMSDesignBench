M62649682 n1 vinp ntail 0 nch W=2u L=0.18u
M584244664 vout vinn ntail 0 nch W=2u L=0.18u
M507510043 ntail vbias_n 0 0 nch W=1u L=0.5u
M133129144 vout n1 VDD VDD pch W=4u L=0.18u
M13134632 n1 n1 VDD VDD pch W=4u L=0.18u
VDD VDD 0 1.8
C566503380 vout 0 1p
