M679840341 n1 vinp ntail 0 nch W=2u L=0.18u
M716838167 vout vinn ntail 0 nch W=2u L=0.18u
M829029675 ntail vbias_n 0 0 nch W=1u L=0.5u
M911607254 vout n1 VDD VDD pch W=4u L=0.18u
M245552654 n1 n1 VDD VDD pch W=4u L=0.18u
VDD VDD 0 1.8
C539324091 vout 0 1p
