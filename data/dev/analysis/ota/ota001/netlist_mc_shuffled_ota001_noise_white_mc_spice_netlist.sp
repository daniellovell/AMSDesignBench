M464618031 n1 vinp ntail 0 nch W=2u L=0.18u
M937715901 vout vinn ntail 0 nch W=2u L=0.18u
M283890374 ntail vbias_n 0 0 nch W=1u L=0.5u
M756259023 vout n1 VDD VDD pch W=4u L=0.18u
M573360947 n1 n1 VDD VDD pch W=4u L=0.18u
VDD VDD 0 1.8
C797505163 vout 0 1p
