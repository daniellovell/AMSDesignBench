M572151320 n1 vinp ntail 0 nch W=2u L=0.18u
M465056870 vout vinn ntail 0 nch W=2u L=0.18u
M126904956 ntail vbias_n 0 0 nch W=1u L=0.5u
M463399213 vout n1 VDD VDD pch W=4u L=0.18u
M218926764 n1 n1 VDD VDD pch W=4u L=0.18u
VDD VDD 0 1.8
C830113043 vout 0 1p
