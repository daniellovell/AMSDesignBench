M165313478 n1 vinp ntail 0 nch W=2u L=0.18u
M258520965 vout vinn ntail 0 nch W=2u L=0.18u
M776305784 ntail vbias_n 0 0 nch W=1u L=0.5u
M313165923 vout n1 VDD VDD pch W=4u L=0.18u
M227711653 n1 n1 VDD VDD pch W=4u L=0.18u
VDD VDD 0 1.8
C122809382 vout 0 1p
