M429475892 n1 vinp ntail 0 nch W=2u L=0.18u
M771781745 vout vinn ntail 0 nch W=2u L=0.18u
M965336576 ntail vbias_n 0 0 nch W=1u L=0.5u
M224404915 vout n1 VDD VDD pch W=4u L=0.18u
M956456929 n1 n1 VDD VDD pch W=4u L=0.18u
VDD VDD 0 1.8
C232391627 vout 0 1p
