M504209859 n1 vinp ntail 0 nch W=2u L=0.18u
M822848566 vout vinn ntail 0 nch W=2u L=0.18u
M55010510 ntail vbias_n 0 0 nch W=1u L=0.5u
M167884447 vout n1 VDD VDD pch W=4u L=0.18u
M260778849 n1 n1 VDD VDD pch W=4u L=0.18u
VDD VDD 0 1.8
C191518730 vout 0 1p
