M728527213 n1 vinp ntail 0 nch W=2u L=0.18u
M516264010 vout vinn ntail 0 nch W=2u L=0.18u
M564118378 ntail vbias_n 0 0 nch W=1u L=0.5u
M261695681 vout n1 VDD VDD pch W=4u L=0.18u
M947535315 n1 n1 VDD VDD pch W=4u L=0.18u
VDD VDD 0 1.8
C552911018 vout 0 1p
