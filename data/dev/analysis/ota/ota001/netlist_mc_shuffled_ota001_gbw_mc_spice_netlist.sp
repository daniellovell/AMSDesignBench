M297472413 n1 vinp ntail 0 nch W=2u L=0.18u
M702821498 vout vinn ntail 0 nch W=2u L=0.18u
M494711944 ntail vbias_n 0 0 nch W=1u L=0.5u
M33187368 vout n1 VDD VDD pch W=4u L=0.18u
M841964083 n1 n1 VDD VDD pch W=4u L=0.18u
VDD VDD 0 1.8
C548882300 vout 0 1p
