M780816830 n1 vinp ntail 0 nch W=2u L=0.18u
M22351956 vout vinn ntail 0 nch W=2u L=0.18u
M691180272 ntail vbias_n 0 0 nch W=1u L=0.5u
M358196666 vout n1 VDD VDD pch W=4u L=0.18u
M612455789 n1 n1 VDD VDD pch W=4u L=0.18u
VDD VDD 0 1.8
C511655316 vout 0 1p
