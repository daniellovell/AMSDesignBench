M4469951 n1 vinp ntail 0 nch W=2u L=0.18u
M36128673 vout vinn ntail 0 nch W=2u L=0.18u
M593294394 ntail vbias_n 0 0 nch W=1u L=0.5u
M145016386 vout n1 VDD VDD pch W=4u L=0.18u
M434546780 n1 n1 VDD VDD pch W=4u L=0.18u
VDD VDD 0 1.8
C823884815 vout 0 1p
