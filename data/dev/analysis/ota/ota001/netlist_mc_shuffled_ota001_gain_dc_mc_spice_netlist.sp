M484920489 n1 vinp ntail 0 nch W=2u L=0.18u
M145702347 vout vinn ntail 0 nch W=2u L=0.18u
M767975202 ntail vbias_n 0 0 nch W=1u L=0.5u
M978277222 vout n1 VDD VDD pch W=4u L=0.18u
M315764786 n1 n1 VDD VDD pch W=4u L=0.18u
VDD VDD 0 1.8
C552745683 vout 0 1p
