M29866508 n1 vinp ntail 0 nch W=2u L=0.18u
M656125336 vout vinn ntail 0 nch W=2u L=0.18u
M56035178 ntail vbias_n 0 0 nch W=1u L=0.5u
M296178542 vout n1 VDD VDD pch W=4u L=0.18u
M50908967 n1 n1 VDD VDD pch W=4u L=0.18u
VDD VDD 0 1.8
C716892091 vout 0 1p
