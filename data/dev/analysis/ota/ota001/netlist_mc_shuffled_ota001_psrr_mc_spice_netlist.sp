M456864930 n1 vinp ntail 0 nch W=2u L=0.18u
M787307385 vout vinn ntail 0 nch W=2u L=0.18u
M688745732 ntail vbias_n 0 0 nch W=1u L=0.5u
M215649855 vout n1 VDD VDD pch W=4u L=0.18u
M737846606 n1 n1 VDD VDD pch W=4u L=0.18u
VDD VDD 0 1.8
C471968455 vout 0 1p
