M851714249 n1 vinp ntail 0 nch W=2u L=0.18u
M925911079 vout vinn ntail 0 nch W=2u L=0.18u
M927331809 ntail vbias_n 0 0 nch W=1u L=0.5u
M383376757 vout n1 VDD VDD pch W=4u L=0.18u
M42607870 n1 n1 VDD VDD pch W=4u L=0.18u
VDD VDD 0 1.8
C31203239 vout 0 1p
