M734028442 N005 vin 0 0 NMOS l=0.5u w=50u
M677162485 vout N004 N005 0 NMOS l=0.5u w=50u
M870953738 N001 N002 vout VDD PMOS l=0.5u w=75u
M474630871 VDD vb3 N001 VDD PMOS l=0.5u w=100u
M389665970 VDD N001 N002 VDD PMOS l=0.5u w=100u
M581168356 VDD vb1 N004 VDD PMOS l=0.8u w=82u
M693036690 N004 N005 0 0 NMOS l=0.8u w=11u
M424738481 N002 vb2 0 0 NMOS l=1.0u w=1u
VDD VDD 0 1.8
C337917093 vout 0 5p
