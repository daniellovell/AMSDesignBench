M219051112 N005 vin 0 0 NMOS l=0.5u w=50u
M488901562 vout N004 N005 0 NMOS l=0.5u w=50u
M164555979 N001 N002 vout VDD PMOS l=0.5u w=75u
M486987117 VDD vb3 N001 VDD PMOS l=0.5u w=100u
M991800586 VDD N001 N002 VDD PMOS l=0.5u w=100u
M968781391 VDD vb1 N004 VDD PMOS l=0.8u w=82u
M22985647 N004 N005 0 0 NMOS l=0.8u w=11u
M152759419 N002 vb2 0 0 NMOS l=1.0u w=1u
VDD VDD 0 1.8
C434502506 vout 0 5p
