M280568150 N005 vin 0 0 NMOS l=0.5u w=50u
M578316433 vout N004 N005 0 NMOS l=0.5u w=50u
M666294488 N001 N002 vout VDD PMOS l=0.5u w=75u
M720022084 VDD vb3 N001 VDD PMOS l=0.5u w=100u
M539299245 VDD N001 N002 VDD PMOS l=0.5u w=100u
M139511926 VDD vb1 N004 VDD PMOS l=0.8u w=82u
M493328702 N004 N005 0 0 NMOS l=0.8u w=11u
M483514954 N002 vb2 0 0 NMOS l=1.0u w=1u
VDD VDD 0 1.8
C22540930 vout 0 5p
