M893602672 N005 vin 0 0 NMOS l=0.5u w=50u
M155765435 vout N004 N005 0 NMOS l=0.5u w=50u
M796540330 N001 N002 vout VDD PMOS l=0.5u w=75u
M671420756 VDD vb3 N001 VDD PMOS l=0.5u w=100u
M126832667 VDD N001 N002 VDD PMOS l=0.5u w=100u
M643622035 VDD vb1 N004 VDD PMOS l=0.8u w=82u
M624488242 N004 N005 0 0 NMOS l=0.8u w=11u
M266963901 N002 vb2 0 0 NMOS l=1.0u w=1u
VDD VDD 0 1.8
C951446718 vout 0 5p
