M740498486 N005 vin 0 0 NMOS l=0.5u w=50u
M635178035 vout N004 N005 0 NMOS l=0.5u w=50u
M456338103 N001 N002 vout VDD PMOS l=0.5u w=75u
M223119214 VDD vb3 N001 VDD PMOS l=0.5u w=100u
M2762773 VDD N001 N002 VDD PMOS l=0.5u w=100u
M553249305 VDD vb1 N004 VDD PMOS l=0.8u w=82u
M155693106 N004 N005 0 0 NMOS l=0.8u w=11u
M483652556 N002 vb2 0 0 NMOS l=1.0u w=1u
VDD VDD 0 1.8
C601368002 vout 0 5p
