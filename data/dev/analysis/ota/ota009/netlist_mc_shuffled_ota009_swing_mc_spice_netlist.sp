M554917701 N005 vin 0 0 NMOS l=0.5u w=50u
M345600332 vout N004 N005 0 NMOS l=0.5u w=50u
M509148315 N001 N002 vout VDD PMOS l=0.5u w=75u
M73539518 VDD vb3 N001 VDD PMOS l=0.5u w=100u
M831423881 VDD N001 N002 VDD PMOS l=0.5u w=100u
M431025333 VDD vb1 N004 VDD PMOS l=0.8u w=82u
M510957154 N004 N005 0 0 NMOS l=0.8u w=11u
M976992940 N002 vb2 0 0 NMOS l=1.0u w=1u
VDD VDD 0 1.8
C778307177 vout 0 5p
