M712372495 N005 vin 0 0 NMOS l=0.5u w=50u
M761626093 vout N004 N005 0 NMOS l=0.5u w=50u
M199611550 N001 N002 vout VDD PMOS l=0.5u w=75u
M959056129 VDD vb3 N001 VDD PMOS l=0.5u w=100u
M575027045 VDD N001 N002 VDD PMOS l=0.5u w=100u
M91644487 VDD vb1 N004 VDD PMOS l=0.8u w=82u
M235984372 N004 N005 0 0 NMOS l=0.8u w=11u
M464703068 N002 vb2 0 0 NMOS l=1.0u w=1u
VDD VDD 0 1.8
C354544102 vout 0 5p
