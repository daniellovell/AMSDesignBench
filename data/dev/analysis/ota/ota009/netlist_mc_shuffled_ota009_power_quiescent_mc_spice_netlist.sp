M154566798 N005 vin 0 0 NMOS l=0.5u w=50u
M372022315 vout N004 N005 0 NMOS l=0.5u w=50u
M371043420 N001 N002 vout VDD PMOS l=0.5u w=75u
M612117611 VDD vb3 N001 VDD PMOS l=0.5u w=100u
M855466960 VDD N001 N002 VDD PMOS l=0.5u w=100u
M729806688 VDD vb1 N004 VDD PMOS l=0.8u w=82u
M128921062 N004 N005 0 0 NMOS l=0.8u w=11u
M574432451 N002 vb2 0 0 NMOS l=1.0u w=1u
VDD VDD 0 1.8
C403039078 vout 0 5p
