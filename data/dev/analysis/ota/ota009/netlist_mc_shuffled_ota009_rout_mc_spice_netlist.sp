M639947942 N005 vin 0 0 NMOS l=0.5u w=50u
M803736262 vout N004 N005 0 NMOS l=0.5u w=50u
M879916847 N001 N002 vout VDD PMOS l=0.5u w=75u
M127713029 VDD vb3 N001 VDD PMOS l=0.5u w=100u
M604699382 VDD N001 N002 VDD PMOS l=0.5u w=100u
M628882544 VDD vb1 N004 VDD PMOS l=0.8u w=82u
M721680792 N004 N005 0 0 NMOS l=0.8u w=11u
M13483701 N002 vb2 0 0 NMOS l=1.0u w=1u
VDD VDD 0 1.8
C860501812 vout 0 5p
