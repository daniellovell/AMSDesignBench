M926691764 N005 vin 0 0 NMOS l=0.5u w=50u
M327899868 vout N004 N005 0 NMOS l=0.5u w=50u
M680304949 N001 N002 vout VDD PMOS l=0.5u w=75u
M486090700 VDD vb3 N001 VDD PMOS l=0.5u w=100u
M322608324 VDD N001 N002 VDD PMOS l=0.5u w=100u
M952669344 VDD vb1 N004 VDD PMOS l=0.8u w=82u
M741311783 N004 N005 0 0 NMOS l=0.8u w=11u
M279846406 N002 vb2 0 0 NMOS l=1.0u w=1u
VDD VDD 0 1.8
C753637387 vout 0 5p
