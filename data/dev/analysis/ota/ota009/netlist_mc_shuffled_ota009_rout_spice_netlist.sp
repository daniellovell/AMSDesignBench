M951690672 N005 vin 0 0 NMOS l=0.5u w=50u
M489576486 vout N004 N005 0 NMOS l=0.5u w=50u
M259563620 N001 N002 vout VDD PMOS l=0.5u w=75u
M8064056 VDD vb3 N001 VDD PMOS l=0.5u w=100u
M650334578 VDD N001 N002 VDD PMOS l=0.5u w=100u
M482267328 VDD vb1 N004 VDD PMOS l=0.8u w=82u
M67351320 N004 N005 0 0 NMOS l=0.8u w=11u
M705331168 N002 vb2 0 0 NMOS l=1.0u w=1u
VDD VDD 0 1.8
C387982846 vout 0 5p
