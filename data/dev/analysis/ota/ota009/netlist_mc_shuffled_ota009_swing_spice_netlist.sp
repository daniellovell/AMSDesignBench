M549319553 N005 vin 0 0 NMOS l=0.5u w=50u
M356280608 vout N004 N005 0 NMOS l=0.5u w=50u
M413174125 N001 N002 vout VDD PMOS l=0.5u w=75u
M206146966 VDD vb3 N001 VDD PMOS l=0.5u w=100u
M245951421 VDD N001 N002 VDD PMOS l=0.5u w=100u
M776706094 VDD vb1 N004 VDD PMOS l=0.8u w=82u
M37529730 N004 N005 0 0 NMOS l=0.8u w=11u
M758722311 N002 vb2 0 0 NMOS l=1.0u w=1u
VDD VDD 0 1.8
C917293955 vout 0 5p
