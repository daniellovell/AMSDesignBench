M915260591 N005 vin 0 0 NMOS l=0.5u w=50u
M758935140 vout N004 N005 0 NMOS l=0.5u w=50u
M785580503 N001 N002 vout VDD PMOS l=0.5u w=75u
M218744314 VDD vb3 N001 VDD PMOS l=0.5u w=100u
M101817826 VDD N001 N002 VDD PMOS l=0.5u w=100u
M132804452 VDD vb1 N004 VDD PMOS l=0.8u w=82u
M232679314 N004 N005 0 0 NMOS l=0.8u w=11u
M555724861 N002 vb2 0 0 NMOS l=1.0u w=1u
VDD VDD 0 1.8
C756021948 vout 0 5p
