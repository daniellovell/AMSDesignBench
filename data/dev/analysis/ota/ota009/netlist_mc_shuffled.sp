M525143891 N005 vin 0 0 NMOS l=0.5u w=50u
M738644063 vout N004 N005 0 NMOS l=0.5u w=50u
M727709187 N001 N002 vout VDD PMOS l=0.5u w=75u
M501977946 VDD vb3 N001 VDD PMOS l=0.5u w=100u
M111135496 VDD N001 N002 VDD PMOS l=0.5u w=100u
M651620427 VDD vb1 N004 VDD PMOS l=0.8u w=82u
M284780693 N004 N005 0 0 NMOS l=0.8u w=11u
M713399564 N002 vb2 0 0 NMOS l=1.0u w=1u
VDD VDD 0 1.8
C66732441 vout 0 5p
