M305253095 N005 vin 0 0 NMOS l=0.5u w=50u
M386549276 vout N004 N005 0 NMOS l=0.5u w=50u
M184324901 N001 N002 vout VDD PMOS l=0.5u w=75u
M373709250 VDD vb3 N001 VDD PMOS l=0.5u w=100u
M378842527 VDD N001 N002 VDD PMOS l=0.5u w=100u
M330574320 VDD vb1 N004 VDD PMOS l=0.8u w=82u
M485263807 N004 N005 0 0 NMOS l=0.8u w=11u
M940196315 N002 vb2 0 0 NMOS l=1.0u w=1u
VDD VDD 0 1.8
C234987304 vout 0 5p
