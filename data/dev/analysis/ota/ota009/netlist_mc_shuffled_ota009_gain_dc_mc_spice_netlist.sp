M915240227 N005 vin 0 0 NMOS l=0.5u w=50u
M821945608 vout N004 N005 0 NMOS l=0.5u w=50u
M398941986 N001 N002 vout VDD PMOS l=0.5u w=75u
M961547011 VDD vb3 N001 VDD PMOS l=0.5u w=100u
M916867021 VDD N001 N002 VDD PMOS l=0.5u w=100u
M915232586 VDD vb1 N004 VDD PMOS l=0.8u w=82u
M200959017 N004 N005 0 0 NMOS l=0.8u w=11u
M368535801 N002 vb2 0 0 NMOS l=1.0u w=1u
VDD VDD 0 1.8
C864021429 vout 0 5p
