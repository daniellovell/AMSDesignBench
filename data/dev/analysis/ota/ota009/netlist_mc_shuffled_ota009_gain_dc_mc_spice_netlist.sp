M568777128 N005 vin 0 0 NMOS l=0.5u w=50u
M518454554 vout N004 N005 0 NMOS l=0.5u w=50u
M174071082 N001 N002 vout VDD PMOS l=0.5u w=75u
M812981335 VDD vb3 N001 VDD PMOS l=0.5u w=100u
M180683399 VDD N001 N002 VDD PMOS l=0.5u w=100u
M323066346 VDD vb1 N004 VDD PMOS l=0.8u w=82u
M757119408 N004 N005 0 0 NMOS l=0.8u w=11u
M351056899 N002 vb2 0 0 NMOS l=1.0u w=1u
VDD VDD 0 1.8
C858169752 vout 0 5p
