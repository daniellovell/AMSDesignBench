M138332862 N005 vin 0 0 NMOS l=0.5u w=50u
M310022525 vout N004 N005 0 NMOS l=0.5u w=50u
M119023304 N001 N002 vout VDD PMOS l=0.5u w=75u
M821316721 VDD vb3 N001 VDD PMOS l=0.5u w=100u
M394826564 VDD N001 N002 VDD PMOS l=0.5u w=100u
M934656732 VDD vb1 N004 VDD PMOS l=0.8u w=82u
M662602035 N004 N005 0 0 NMOS l=0.8u w=11u
M991964257 N002 vb2 0 0 NMOS l=1.0u w=1u
VDD VDD 0 1.8
C553235581 vout 0 5p
