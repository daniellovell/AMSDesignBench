M361457950 N005 vin 0 0 NMOS l=0.5u w=50u
M534407588 vout N004 N005 0 NMOS l=0.5u w=50u
M664260836 N001 N002 vout VDD PMOS l=0.5u w=75u
M253833775 VDD vb3 N001 VDD PMOS l=0.5u w=100u
M175455763 VDD N001 N002 VDD PMOS l=0.5u w=100u
M562129370 VDD vb1 N004 VDD PMOS l=0.8u w=82u
M55630456 N004 N005 0 0 NMOS l=0.8u w=11u
M128142484 N002 vb2 0 0 NMOS l=1.0u w=1u
VDD VDD 0 1.8
C938767757 vout 0 5p
