M319774490 N005 vin 0 0 NMOS l=0.5u w=50u
M358963603 vout N004 N005 0 NMOS l=0.5u w=50u
M558370324 N001 N002 vout VDD PMOS l=0.5u w=75u
M796201998 VDD vb3 N001 VDD PMOS l=0.5u w=100u
M489286828 VDD N001 N002 VDD PMOS l=0.5u w=100u
M952612702 VDD vb1 N004 VDD PMOS l=0.8u w=82u
M485012916 N004 N005 0 0 NMOS l=0.8u w=11u
M739956387 N002 vb2 0 0 NMOS l=1.0u w=1u
VDD VDD 0 1.8
C125108713 vout 0 5p
