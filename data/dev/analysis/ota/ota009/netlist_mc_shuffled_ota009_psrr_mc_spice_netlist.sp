M377500471 N005 vin 0 0 NMOS l=0.5u w=50u
M562785221 vout N004 N005 0 NMOS l=0.5u w=50u
M812205677 N001 N002 vout VDD PMOS l=0.5u w=75u
M973694644 VDD vb3 N001 VDD PMOS l=0.5u w=100u
M156238219 VDD N001 N002 VDD PMOS l=0.5u w=100u
M432020736 VDD vb1 N004 VDD PMOS l=0.8u w=82u
M780840005 N004 N005 0 0 NMOS l=0.8u w=11u
M187610135 N002 vb2 0 0 NMOS l=1.0u w=1u
VDD VDD 0 1.8
C428476507 vout 0 5p
