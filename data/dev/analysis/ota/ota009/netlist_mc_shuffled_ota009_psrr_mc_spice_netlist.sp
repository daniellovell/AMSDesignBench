M680673828 N005 vin 0 0 NMOS l=0.5u w=50u
M457990730 vout N004 N005 0 NMOS l=0.5u w=50u
M403420997 N001 N002 vout VDD PMOS l=0.5u w=75u
M751859241 VDD vb3 N001 VDD PMOS l=0.5u w=100u
M604382839 VDD N001 N002 VDD PMOS l=0.5u w=100u
M380996631 VDD vb1 N004 VDD PMOS l=0.8u w=82u
M520688376 N004 N005 0 0 NMOS l=0.8u w=11u
M409177274 N002 vb2 0 0 NMOS l=1.0u w=1u
VDD VDD 0 1.8
C253842654 vout 0 5p
