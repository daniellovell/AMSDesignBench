M846934982 n1 vinp ntail 0 nch W=2u L=0.18u
M48901332 n2 vinn ntail 0 nch W=2u L=0.18u
M92917642 ntail vbias_n 0 0 nch W=1u L=0.5u
M644684371 n1 n1 VDD VDD pch W=2u L=0.18u
M337495219 n2 n1 VDD VDD pch W=2u L=0.18u
M858491714 nmir n1 VDD VDD pch W=4u L=0.18u
M967671625 vout n1 VDD VDD pch W=4u L=0.18u
M412126297 nmir nmir 0 0 nch W=2u L=0.18u
M451877331 vout nmir 0 0 nch W=2u L=0.18u

VDD VDD 0 1.8
C820704937 vout 0 1p
