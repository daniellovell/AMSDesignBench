M116135346 n1 vinp ntail 0 nch W=2u L=0.18u
M826108686 n2 vinn ntail 0 nch W=2u L=0.18u
M969370243 ntail vbias_n 0 0 nch W=1u L=0.5u
M305559835 n1 n1 VDD VDD pch W=2u L=0.18u
M132364151 n2 n1 VDD VDD pch W=2u L=0.18u
M442464393 nmir n1 VDD VDD pch W=4u L=0.18u
M123577071 vout n1 VDD VDD pch W=4u L=0.18u
M792626624 nmir nmir 0 0 nch W=2u L=0.18u
M193581169 vout nmir 0 0 nch W=2u L=0.18u

VDD VDD 0 1.8
C562102378 vout 0 1p
