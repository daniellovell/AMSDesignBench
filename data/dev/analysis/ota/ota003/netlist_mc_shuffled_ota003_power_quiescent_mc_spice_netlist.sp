M306193482 n1 vinp ntail 0 nch W=2u L=0.18u
M486857054 n2 vinn ntail 0 nch W=2u L=0.18u
M599627946 ntail vbias_n 0 0 nch W=1u L=0.5u
M339681459 n1 n1 VDD VDD pch W=2u L=0.18u
M632060843 n2 n1 VDD VDD pch W=2u L=0.18u
M893831209 nmir n1 VDD VDD pch W=4u L=0.18u
M734656908 vout n1 VDD VDD pch W=4u L=0.18u
M154684827 nmir nmir 0 0 nch W=2u L=0.18u
M517492530 vout nmir 0 0 nch W=2u L=0.18u

VDD VDD 0 1.8
C555167700 vout 0 1p
