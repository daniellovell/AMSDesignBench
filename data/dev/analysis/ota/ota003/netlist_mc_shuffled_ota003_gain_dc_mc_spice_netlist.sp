M222155785 n1 vinp ntail 0 nch W=2u L=0.18u
M16425569 n2 vinn ntail 0 nch W=2u L=0.18u
M976324882 ntail vbias_n 0 0 nch W=1u L=0.5u
M767454190 n1 n1 VDD VDD pch W=2u L=0.18u
M19468488 n2 n1 VDD VDD pch W=2u L=0.18u
M766503136 nmir n1 VDD VDD pch W=4u L=0.18u
M847459463 vout n1 VDD VDD pch W=4u L=0.18u
M602784187 nmir nmir 0 0 nch W=2u L=0.18u
M345525259 vout nmir 0 0 nch W=2u L=0.18u

VDD VDD 0 1.8
C90182476 vout 0 1p
