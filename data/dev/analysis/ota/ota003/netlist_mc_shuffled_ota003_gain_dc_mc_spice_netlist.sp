M525926276 n1 vinp ntail 0 nch W=2u L=0.18u
M226389785 n2 vinn ntail 0 nch W=2u L=0.18u
M860009279 ntail vbias_n 0 0 nch W=1u L=0.5u
M554101022 n1 n1 VDD VDD pch W=2u L=0.18u
M680406233 n2 n1 VDD VDD pch W=2u L=0.18u
M903208759 nmir n1 VDD VDD pch W=4u L=0.18u
M416450167 vout n1 VDD VDD pch W=4u L=0.18u
M627323268 nmir nmir 0 0 nch W=2u L=0.18u
M318486226 vout nmir 0 0 nch W=2u L=0.18u

VDD VDD 0 1.8
C866134645 vout 0 1p
