M115985943 n1 vinp ntail 0 nch W=2u L=0.18u
M287522302 n2 vinn ntail 0 nch W=2u L=0.18u
M734251987 ntail vbias_n 0 0 nch W=1u L=0.5u
M276548956 n1 n1 VDD VDD pch W=2u L=0.18u
M608621693 n2 n1 VDD VDD pch W=2u L=0.18u
M121147949 nmir n1 VDD VDD pch W=4u L=0.18u
M437729435 vout n1 VDD VDD pch W=4u L=0.18u
M405472116 nmir nmir 0 0 nch W=2u L=0.18u
M74224598 vout nmir 0 0 nch W=2u L=0.18u

VDD VDD 0 1.8
C636007975 vout 0 1p
