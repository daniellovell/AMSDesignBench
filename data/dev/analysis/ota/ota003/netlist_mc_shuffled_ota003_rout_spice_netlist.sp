M113504878 n1 vinp ntail 0 nch W=2u L=0.18u
M348712443 n2 vinn ntail 0 nch W=2u L=0.18u
M407944763 ntail vbias_n 0 0 nch W=1u L=0.5u
M219206454 n1 n1 VDD VDD pch W=2u L=0.18u
M698002032 n2 n1 VDD VDD pch W=2u L=0.18u
M936050858 nmir n1 VDD VDD pch W=4u L=0.18u
M635502728 vout n1 VDD VDD pch W=4u L=0.18u
M931894859 nmir nmir 0 0 nch W=2u L=0.18u
M134543846 vout nmir 0 0 nch W=2u L=0.18u

VDD VDD 0 1.8
C131276623 vout 0 1p
