M726829675 n1 vinp ntail 0 nch W=2u L=0.18u
M336437759 n2 vinn ntail 0 nch W=2u L=0.18u
M926553743 ntail vbias_n 0 0 nch W=1u L=0.5u
M934522274 n1 n1 VDD VDD pch W=2u L=0.18u
M160316452 n2 n1 VDD VDD pch W=2u L=0.18u
M500784491 nmir n1 VDD VDD pch W=4u L=0.18u
M769409917 vout n1 VDD VDD pch W=4u L=0.18u
M334999069 nmir nmir 0 0 nch W=2u L=0.18u
M71239742 vout nmir 0 0 nch W=2u L=0.18u

VDD VDD 0 1.8
C977434032 vout 0 1p
