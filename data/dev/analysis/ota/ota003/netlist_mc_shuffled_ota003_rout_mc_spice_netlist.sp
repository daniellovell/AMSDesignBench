M341606218 n1 vinp ntail 0 nch W=2u L=0.18u
M650757684 n2 vinn ntail 0 nch W=2u L=0.18u
M503767117 ntail vbias_n 0 0 nch W=1u L=0.5u
M788298905 n1 n1 VDD VDD pch W=2u L=0.18u
M80698573 n2 n1 VDD VDD pch W=2u L=0.18u
M797680683 nmir n1 VDD VDD pch W=4u L=0.18u
M110117485 vout n1 VDD VDD pch W=4u L=0.18u
M138148007 nmir nmir 0 0 nch W=2u L=0.18u
M935953925 vout nmir 0 0 nch W=2u L=0.18u

VDD VDD 0 1.8
C344741284 vout 0 1p
