M430269497 n1 vinp ntail 0 nch W=2u L=0.18u
M391771742 n2 vinn ntail 0 nch W=2u L=0.18u
M891959741 ntail vbias_n 0 0 nch W=1u L=0.5u
M731481351 n1 n1 VDD VDD pch W=2u L=0.18u
M565270374 n2 n1 VDD VDD pch W=2u L=0.18u
M149095041 nmir n1 VDD VDD pch W=4u L=0.18u
M88693067 vout n1 VDD VDD pch W=4u L=0.18u
M445719202 nmir nmir 0 0 nch W=2u L=0.18u
M866120082 vout nmir 0 0 nch W=2u L=0.18u

VDD VDD 0 1.8
C83215850 vout 0 1p
