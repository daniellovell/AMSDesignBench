M212263957 n1 vinp ntail 0 nch W=2u L=0.18u
M214266652 n2 vinn ntail 0 nch W=2u L=0.18u
M366324695 ntail vbias_n 0 0 nch W=1u L=0.5u
M602634346 n1 n1 VDD VDD pch W=2u L=0.18u
M614271381 n2 n1 VDD VDD pch W=2u L=0.18u
M930711964 nmir n1 VDD VDD pch W=4u L=0.18u
M127672102 vout n1 VDD VDD pch W=4u L=0.18u
M777228074 nmir nmir 0 0 nch W=2u L=0.18u
M651309493 vout nmir 0 0 nch W=2u L=0.18u

VDD VDD 0 1.8
C772833163 vout 0 1p
