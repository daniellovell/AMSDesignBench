M228070297 n1 vinp ntail 0 nch W=2u L=0.18u
M13282131 n2 vinn ntail 0 nch W=2u L=0.18u
M189374581 ntail vbias_n 0 0 nch W=1u L=0.5u
M422974596 n1 n1 VDD VDD pch W=2u L=0.18u
M854180611 n2 n1 VDD VDD pch W=2u L=0.18u
M334667375 nmir n1 VDD VDD pch W=4u L=0.18u
M330767421 vout n1 VDD VDD pch W=4u L=0.18u
M851049732 nmir nmir 0 0 nch W=2u L=0.18u
M579778279 vout nmir 0 0 nch W=2u L=0.18u

VDD VDD 0 1.8
C64843773 vout 0 1p
