M858246145 n1 vinp ntail 0 nch W=2u L=0.18u
M222255790 n2 vinn ntail 0 nch W=2u L=0.18u
M892522530 ntail vbias_n 0 0 nch W=1u L=0.5u
M366070349 n1 n1 VDD VDD pch W=2u L=0.18u
M216574897 n2 n1 VDD VDD pch W=2u L=0.18u
M380443487 nmir n1 VDD VDD pch W=4u L=0.18u
M346339324 vout n1 VDD VDD pch W=4u L=0.18u
M484076792 nmir nmir 0 0 nch W=2u L=0.18u
M163771141 vout nmir 0 0 nch W=2u L=0.18u

VDD VDD 0 1.8
C382804494 vout 0 1p
