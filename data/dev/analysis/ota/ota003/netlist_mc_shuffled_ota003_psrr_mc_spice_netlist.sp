M519865464 n1 vinp ntail 0 nch W=2u L=0.18u
M391704098 n2 vinn ntail 0 nch W=2u L=0.18u
M863854431 ntail vbias_n 0 0 nch W=1u L=0.5u
M860727569 n1 n1 VDD VDD pch W=2u L=0.18u
M375084517 n2 n1 VDD VDD pch W=2u L=0.18u
M553670952 nmir n1 VDD VDD pch W=4u L=0.18u
M111520970 vout n1 VDD VDD pch W=4u L=0.18u
M470892504 nmir nmir 0 0 nch W=2u L=0.18u
M396159677 vout nmir 0 0 nch W=2u L=0.18u

VDD VDD 0 1.8
C724820184 vout 0 1p
