M371900496 n1 vinp ntail 0 nch W=2u L=0.18u
M107625557 n2 vinn ntail 0 nch W=2u L=0.18u
M612040068 ntail vbias_n 0 0 nch W=1u L=0.5u
M718656280 n1 n1 VDD VDD pch W=2u L=0.18u
M78591205 n2 n1 VDD VDD pch W=2u L=0.18u
M595070691 nmir n1 VDD VDD pch W=4u L=0.18u
M775293785 vout n1 VDD VDD pch W=4u L=0.18u
M945529728 nmir nmir 0 0 nch W=2u L=0.18u
M377312325 vout nmir 0 0 nch W=2u L=0.18u

VDD VDD 0 1.8
C305885512 vout 0 1p
