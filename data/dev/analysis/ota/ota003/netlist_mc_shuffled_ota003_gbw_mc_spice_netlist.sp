M792513998 n1 vinp ntail 0 nch W=2u L=0.18u
M969818618 n2 vinn ntail 0 nch W=2u L=0.18u
M397818732 ntail vbias_n 0 0 nch W=1u L=0.5u
M373132847 n1 n1 VDD VDD pch W=2u L=0.18u
M178816889 n2 n1 VDD VDD pch W=2u L=0.18u
M14750171 nmir n1 VDD VDD pch W=4u L=0.18u
M755029277 vout n1 VDD VDD pch W=4u L=0.18u
M943409664 nmir nmir 0 0 nch W=2u L=0.18u
M811446024 vout nmir 0 0 nch W=2u L=0.18u

VDD VDD 0 1.8
C813931947 vout 0 1p
