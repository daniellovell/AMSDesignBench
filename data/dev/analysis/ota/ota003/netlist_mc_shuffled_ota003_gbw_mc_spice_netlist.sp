M189033531 n1 vinp ntail 0 nch W=2u L=0.18u
M618366483 n2 vinn ntail 0 nch W=2u L=0.18u
M103395711 ntail vbias_n 0 0 nch W=1u L=0.5u
M378092547 n1 n1 VDD VDD pch W=2u L=0.18u
M637523651 n2 n1 VDD VDD pch W=2u L=0.18u
M146407833 nmir n1 VDD VDD pch W=4u L=0.18u
M951638428 vout n1 VDD VDD pch W=4u L=0.18u
M373596774 nmir nmir 0 0 nch W=2u L=0.18u
M780393804 vout nmir 0 0 nch W=2u L=0.18u

VDD VDD 0 1.8
C351812490 vout 0 1p
