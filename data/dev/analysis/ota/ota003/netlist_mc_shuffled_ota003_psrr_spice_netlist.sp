M300385188 n1 vinp ntail 0 nch W=2u L=0.18u
M871012486 n2 vinn ntail 0 nch W=2u L=0.18u
M864284426 ntail vbias_n 0 0 nch W=1u L=0.5u
M318033689 n1 n1 VDD VDD pch W=2u L=0.18u
M658010983 n2 n1 VDD VDD pch W=2u L=0.18u
M227378063 nmir n1 VDD VDD pch W=4u L=0.18u
M167814726 vout n1 VDD VDD pch W=4u L=0.18u
M761017267 nmir nmir 0 0 nch W=2u L=0.18u
M280346901 vout nmir 0 0 nch W=2u L=0.18u

VDD VDD 0 1.8
C669289591 vout 0 1p
