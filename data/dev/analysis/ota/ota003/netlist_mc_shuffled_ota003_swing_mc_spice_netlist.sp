M579841538 n1 vinp ntail 0 nch W=2u L=0.18u
M426890273 n2 vinn ntail 0 nch W=2u L=0.18u
M732768424 ntail vbias_n 0 0 nch W=1u L=0.5u
M780728868 n1 n1 VDD VDD pch W=2u L=0.18u
M878675674 n2 n1 VDD VDD pch W=2u L=0.18u
M664534828 nmir n1 VDD VDD pch W=4u L=0.18u
M340677029 vout n1 VDD VDD pch W=4u L=0.18u
M193003284 nmir nmir 0 0 nch W=2u L=0.18u
M739063217 vout nmir 0 0 nch W=2u L=0.18u

VDD VDD 0 1.8
C698250257 vout 0 1p
