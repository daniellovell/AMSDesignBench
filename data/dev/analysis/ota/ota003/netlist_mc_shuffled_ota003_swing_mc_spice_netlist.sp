M328542200 n1 vinp ntail 0 nch W=2u L=0.18u
M991036711 n2 vinn ntail 0 nch W=2u L=0.18u
M821242878 ntail vbias_n 0 0 nch W=1u L=0.5u
M627945947 n1 n1 VDD VDD pch W=2u L=0.18u
M392587787 n2 n1 VDD VDD pch W=2u L=0.18u
M402007209 nmir n1 VDD VDD pch W=4u L=0.18u
M457109581 vout n1 VDD VDD pch W=4u L=0.18u
M661583904 nmir nmir 0 0 nch W=2u L=0.18u
M249969357 vout nmir 0 0 nch W=2u L=0.18u

VDD VDD 0 1.8
C934782618 vout 0 1p
