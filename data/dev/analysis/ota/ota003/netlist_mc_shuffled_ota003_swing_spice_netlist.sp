M316501115 n1 vinp ntail 0 nch W=2u L=0.18u
M787320534 n2 vinn ntail 0 nch W=2u L=0.18u
M190425232 ntail vbias_n 0 0 nch W=1u L=0.5u
M282107240 n1 n1 VDD VDD pch W=2u L=0.18u
M475798620 n2 n1 VDD VDD pch W=2u L=0.18u
M79717357 nmir n1 VDD VDD pch W=4u L=0.18u
M594713113 vout n1 VDD VDD pch W=4u L=0.18u
M311801884 nmir nmir 0 0 nch W=2u L=0.18u
M112959272 vout nmir 0 0 nch W=2u L=0.18u

VDD VDD 0 1.8
C674471179 vout 0 1p
