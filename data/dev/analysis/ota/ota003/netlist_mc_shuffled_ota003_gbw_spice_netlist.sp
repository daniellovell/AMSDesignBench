M97891063 n1 vinp ntail 0 nch W=2u L=0.18u
M682789372 n2 vinn ntail 0 nch W=2u L=0.18u
M348649456 ntail vbias_n 0 0 nch W=1u L=0.5u
M27927374 n1 n1 VDD VDD pch W=2u L=0.18u
M879049419 n2 n1 VDD VDD pch W=2u L=0.18u
M526558720 nmir n1 VDD VDD pch W=4u L=0.18u
M812503109 vout n1 VDD VDD pch W=4u L=0.18u
M120259234 nmir nmir 0 0 nch W=2u L=0.18u
M529498668 vout nmir 0 0 nch W=2u L=0.18u

VDD VDD 0 1.8
C54627549 vout 0 1p
