M401201961 vout vin 0 0 NMOS l=0.18u w=2u
M701670712 VDD vb1 vout VDD PMOS l=0.18u w=4u
VDD VDD 0 1.8
C341307914 vout 0 1p
