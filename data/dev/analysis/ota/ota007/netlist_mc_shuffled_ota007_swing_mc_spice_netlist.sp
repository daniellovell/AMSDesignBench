M770527505 vout vin 0 0 NMOS l=0.18u w=2u
M235500129 VDD vb1 vout VDD PMOS l=0.18u w=4u
VDD VDD 0 1.8
C402229675 vout 0 1p
