M519207859 vout vin 0 0 NMOS l=0.18u w=2u
M9775770 VDD vb1 vout VDD PMOS l=0.18u w=4u
VDD VDD 0 1.8
C476681197 vout 0 1p
