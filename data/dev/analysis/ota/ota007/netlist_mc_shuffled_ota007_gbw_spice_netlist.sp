M66567988 vout vin 0 0 NMOS l=0.18u w=2u
M38733320 VDD vb1 vout VDD PMOS l=0.18u w=4u
VDD VDD 0 1.8
C461857431 vout 0 1p
