Vin vin 0 AC 1
R361754999 vin nA BLANK
R513091837 nA vout BLANK
C950075914 nA 0 BLANK
C114952654 vin nB BLANK
C91305718 nB vout BLANK
R301154872 nB 0 BLANK
R97907739 vout 0 BLANK

.end
