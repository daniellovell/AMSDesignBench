Vin vin 0 AC 1
R11059349 vin nA BLANK
R95391851 nA vout BLANK
C581796766 nA 0 BLANK
C741542481 vin nB BLANK
C960106370 nB vout BLANK
R223718333 nB 0 BLANK
R343667833 vout 0 BLANK

.end
