Vin vin 0 AC 1
R247875271 vin nA BLANK
R266187276 nA vout BLANK
C234016196 nA 0 BLANK
C502822131 vin nB BLANK
C418476155 nB vout BLANK
R453115396 nB 0 BLANK
R37816918 vout 0 BLANK

.end
