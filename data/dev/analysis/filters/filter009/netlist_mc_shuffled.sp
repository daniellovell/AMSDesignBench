Vin vin 0 AC 1
R326379199 vin nA BLANK
R643610543 nA vout BLANK
C230787920 nA 0 BLANK
C71715041 vin nB BLANK
C176218585 nB vout BLANK
R249796903 nB 0 BLANK
R816268778 vout 0 BLANK

.end
