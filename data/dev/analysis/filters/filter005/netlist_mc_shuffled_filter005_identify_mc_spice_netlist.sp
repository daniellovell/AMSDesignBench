Vin vin 0 AC 1
R874463243 vin n1 BLANK
R903689187 n1 v1 BLANK
C143963402 n1 0 BLANK
C435215745 v1 n1 BLANK
XU1 v1 n1i v1 OPAMP
R688129362 n1i 0 BLANK
R135164384 v1 n1i BLANK

R618896093 v1 n2 BLANK
R994414642 n2 vout BLANK
C322030510 n2 0 BLANK
C323954753 vout n2 BLANK
XU2 vout n2i vout OPAMP
R531640798 n2i 0 BLANK
R980748369 vout n2i BLANK

R168453998 vout 0 BLANK

.end
