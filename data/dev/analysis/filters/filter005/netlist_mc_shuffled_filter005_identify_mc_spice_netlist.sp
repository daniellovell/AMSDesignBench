Vin vin 0 AC 1
R146489089 vin n1 BLANK
R843399258 n1 v1 BLANK
C935520427 n1 0 BLANK
C825868097 v1 n1 BLANK
XU1 v1 n1i v1 OPAMP
R259076007 n1i 0 BLANK
R6156657 v1 n1i BLANK

R408768436 v1 n2 BLANK
R500725217 n2 vout BLANK
C883549359 n2 0 BLANK
C314448917 vout n2 BLANK
XU2 vout n2i vout OPAMP
R55783661 n2i 0 BLANK
R591424879 vout n2i BLANK

R989781170 vout 0 BLANK

.end
