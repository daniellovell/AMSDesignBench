Vin vin 0 AC 1
R627257681 vin n1 BLANK
R49953552 n1 v1 BLANK
C111822466 n1 0 BLANK
C756761219 v1 n1 BLANK
XU1 v1 n1i v1 OPAMP
R36767130 n1i 0 BLANK
R894760877 v1 n1i BLANK

R83167410 v1 n2 BLANK
R531926045 n2 vout BLANK
C87329740 n2 0 BLANK
C11862463 vout n2 BLANK
XU2 vout n2i vout OPAMP
R621658231 n2i 0 BLANK
R966009812 vout n2i BLANK

R199474653 vout 0 BLANK

.end
