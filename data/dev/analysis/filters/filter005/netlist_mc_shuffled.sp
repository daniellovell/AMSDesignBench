Vin vin 0 AC 1
R270232906 vin n1 BLANK
R842640155 n1 v1 BLANK
C472938323 n1 0 BLANK
C864889877 v1 n1 BLANK
XU1 v1 n1i v1 OPAMP
R489410091 n1i 0 BLANK
R730156757 v1 n1i BLANK

R826741918 v1 n2 BLANK
R30927895 n2 vout BLANK
C566568399 n2 0 BLANK
C558516963 vout n2 BLANK
XU2 vout n2i vout OPAMP
R919584225 n2i 0 BLANK
R416013413 vout n2i BLANK

R484475267 vout 0 BLANK

.end
