Vin vin 0 AC 1

R999355806 vin nsum BLANK
R24038306 z nsum BLANK
R793123664 vout nsum BLANK
XU1 u nsum 0 OPAMP

R861478306 u n2 BLANK
C349004088 vout n2 BLANK
XU2 vout n2 0 OPAMP

R847442934 vout n3 BLANK
C490845530 z n3 BLANK
XU3 z n3 0 OPAMP

R703026330 vout 0 BLANK

.end
