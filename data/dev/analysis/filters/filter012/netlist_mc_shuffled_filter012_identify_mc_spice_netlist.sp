Vin vin 0 AC 1

R858967456 vin nsum BLANK
R667609956 z nsum BLANK
R692059449 vout nsum BLANK
XU1 u nsum 0 OPAMP

R880468136 u n2 BLANK
C613372102 vout n2 BLANK
XU2 vout n2 0 OPAMP

R232154508 vout n3 BLANK
C863710576 z n3 BLANK
XU3 z n3 0 OPAMP

R233149504 vout 0 BLANK

.end
