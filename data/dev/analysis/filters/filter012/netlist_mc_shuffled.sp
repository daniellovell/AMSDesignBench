Vin vin 0 AC 1

R34383948 vin nsum BLANK
R279707794 z nsum BLANK
R761247943 vout nsum BLANK
XU1 u nsum 0 OPAMP

R50824917 u n2 BLANK
C660355968 vout n2 BLANK
XU2 vout n2 0 OPAMP

R909925550 vout n3 BLANK
C524977202 z n3 BLANK
XU3 z n3 0 OPAMP

R572456091 vout 0 BLANK

.end
