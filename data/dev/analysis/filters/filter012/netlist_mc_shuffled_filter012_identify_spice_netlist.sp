Vin vin 0 AC 1

R521268561 vin nsum BLANK
R520639479 z nsum BLANK
R931741797 vout nsum BLANK
XU1 u nsum 0 OPAMP

R395073628 u n2 BLANK
C881818161 vout n2 BLANK
XU2 vout n2 0 OPAMP

R581265241 vout n3 BLANK
C423616627 z n3 BLANK
XU3 z n3 0 OPAMP

R151786586 vout 0 BLANK

.end
