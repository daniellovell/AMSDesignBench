Vin vin 0 AC 1
R486662444 vin vout BLANK
L844250218 vout 0 BLANK
C832006908 vout 0 BLANK
R24888780 vout 0 BLANK
