Vin vin 0 AC 1
R578906012 vin vout BLANK
L749467130 vout 0 BLANK
C576284410 vout 0 BLANK
R712027848 vout 0 BLANK
