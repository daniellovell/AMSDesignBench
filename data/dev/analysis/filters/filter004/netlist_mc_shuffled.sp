Vin vin 0 AC 1
R505243975 vin vout BLANK
L202682937 vout 0 BLANK
C92597202 vout 0 BLANK
R215265440 vout 0 BLANK
