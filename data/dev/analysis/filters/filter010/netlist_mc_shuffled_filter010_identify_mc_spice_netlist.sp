Vin vin 0 AC 1
C809861373 vin n1 BLANK
C685057899 n1 vout BLANK
R926139353 n1 0 BLANK
R209772171 vout 0 BLANK
XU1 vout vout n1 OPAMP
R132311856 vout 0 BLANK

.end
