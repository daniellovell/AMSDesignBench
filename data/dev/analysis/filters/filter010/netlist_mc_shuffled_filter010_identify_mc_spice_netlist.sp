Vin vin 0 AC 1
C592821813 vin n1 BLANK
C890289554 n1 vout BLANK
R48879726 n1 0 BLANK
R718708753 vout 0 BLANK
XU1 vout vout n1 OPAMP
R966294432 vout 0 BLANK

.end
