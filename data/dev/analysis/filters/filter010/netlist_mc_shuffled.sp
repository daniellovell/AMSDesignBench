Vin vin 0 AC 1
C292667033 vin n1 BLANK
C641196703 n1 vout BLANK
R529743225 n1 0 BLANK
R390617825 vout 0 BLANK
XU1 vout vout n1 OPAMP
R148233781 vout 0 BLANK

.end
