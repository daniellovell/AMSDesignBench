Vin vin 0 AC 1
C135915495 vin n1 BLANK
C597398589 n1 vout BLANK
R325786870 n1 0 BLANK
R239734494 vout 0 BLANK
XU1 vout vout n1 OPAMP
R993603842 vout 0 BLANK

.end
