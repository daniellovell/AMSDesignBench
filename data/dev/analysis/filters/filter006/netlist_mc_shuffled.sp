Vin vin 0 AC 1
R744544936 vin n1 BLANK
R849311967 n1 v1 BLANK
C678916593 n1 0 BLANK
C606811160 v1 n1 BLANK
XU1 v1 n1i v1 OPAMP
R204589206 n1i 0 BLANK
R117270350 v1 n1i BLANK

R220792564 v1 n2 BLANK
R407214468 n2 vout BLANK
C518586338 n2 0 BLANK
C775312001 vout n2 BLANK
XU2 vout n2i vout OPAMP
R570910047 n2i 0 BLANK
R388588650 vout n2i BLANK

R646413525 vout 0 BLANK

.end
