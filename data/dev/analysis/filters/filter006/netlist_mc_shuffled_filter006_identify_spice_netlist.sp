Vin vin 0 AC 1
R368322840 vin n1 BLANK
R192045248 n1 v1 BLANK
C719568419 n1 0 BLANK
C218476524 v1 n1 BLANK
XU1 v1 n1i v1 OPAMP
R148617865 n1i 0 BLANK
R760640523 v1 n1i BLANK

R545149201 v1 n2 BLANK
R160359320 n2 vout BLANK
C940040481 n2 0 BLANK
C161216155 vout n2 BLANK
XU2 vout n2i vout OPAMP
R552242526 n2i 0 BLANK
R125944428 vout n2i BLANK

R521881560 vout 0 BLANK

.end
