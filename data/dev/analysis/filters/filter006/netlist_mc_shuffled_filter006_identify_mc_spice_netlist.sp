Vin vin 0 AC 1
R898675871 vin n1 BLANK
R81459272 n1 v1 BLANK
C308291487 n1 0 BLANK
C612992873 v1 n1 BLANK
XU1 v1 n1i v1 OPAMP
R649618609 n1i 0 BLANK
R491118262 v1 n1i BLANK

R57584895 v1 n2 BLANK
R285507715 n2 vout BLANK
C515164093 n2 0 BLANK
C245897292 vout n2 BLANK
XU2 vout n2i vout OPAMP
R208877061 n2i 0 BLANK
R961064295 vout n2i BLANK

R485978172 vout 0 BLANK

.end
