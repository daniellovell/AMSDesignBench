Vin vin 0 AC 1
R286375512 vin n1 BLANK
R308830611 n1 v1 BLANK
C551639454 n1 0 BLANK
C357595282 v1 n1 BLANK
XU1 v1 n1i v1 OPAMP
R814985346 n1i 0 BLANK
R909520926 v1 n1i BLANK

R373964898 v1 n2 BLANK
R220869775 n2 vout BLANK
C333942509 n2 0 BLANK
C261895767 vout n2 BLANK
XU2 vout n2i vout OPAMP
R450357215 n2i 0 BLANK
R84076473 vout n2i BLANK

R283537382 vout 0 BLANK

.end
