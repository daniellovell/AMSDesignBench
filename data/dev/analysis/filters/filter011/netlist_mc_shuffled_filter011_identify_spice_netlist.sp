Vin vin 0 AC 1
C62586236 vin n1 BLANK
R343899296 vout n1 BLANK
C42464755 vout n1 BLANK
R305487895 n1 0 BLANK
XU1 vout n1 0 OPAMP
R360873495 vout 0 BLANK

.end
