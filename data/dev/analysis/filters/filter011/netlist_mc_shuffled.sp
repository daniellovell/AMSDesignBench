Vin vin 0 AC 1
C911845867 vin n1 BLANK
R588494066 vout n1 BLANK
C94330429 vout n1 BLANK
R888356744 n1 0 BLANK
XU1 vout n1 0 OPAMP
R760216537 vout 0 BLANK

.end
