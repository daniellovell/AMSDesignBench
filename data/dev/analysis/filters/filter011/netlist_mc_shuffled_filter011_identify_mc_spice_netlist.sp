Vin vin 0 AC 1
C851911431 vin n1 BLANK
R945167745 vout n1 BLANK
C586949164 vout n1 BLANK
R633890067 n1 0 BLANK
XU1 vout n1 0 OPAMP
R170312183 vout 0 BLANK

.end
