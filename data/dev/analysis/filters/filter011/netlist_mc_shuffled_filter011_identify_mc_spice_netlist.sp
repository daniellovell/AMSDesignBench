Vin vin 0 AC 1
C24926284 vin n1 BLANK
R113169238 vout n1 BLANK
C456173073 vout n1 BLANK
R929054051 n1 0 BLANK
XU1 vout n1 0 OPAMP
R82831491 vout 0 BLANK

.end
